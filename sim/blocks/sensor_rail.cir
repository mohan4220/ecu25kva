* ============================================================
* 5V_SENSOR distribution -- why each group gets its own PTC
* Power chain stage 5, spec section 6
* ============================================================
* The sensor supply leaves the box on harness wires, runs along an
* engine, and ends at connectors that get washed, vibrated and
* occasionally levered off with a screwdriver. A short from a 5 V
* sensor supply pin to engine ground is not an exotic fault, it is
* a Tuesday.
*
* The question this block answers is what that short does to the
* OTHER sensors. If one shorted harness takes the rail down, the
* ECU loses rail pressure, boost, oil pressure and coolant
* temperature simultaneously -- and a controller that loses every
* analog input at once cannot tell a wiring fault from an engine
* falling apart.
*
* The OEM pinout already groups sensors by ground return (pin 34
* boost+coolant, 36 EGR+oil, 08 rail alone). This block is the
* supply-side counterpart of that grouping: one resettable fuse
* per group, so a fault is contained to the group that has it.
*
* Modelled as three sensor groups on one 5 V rail:
*     Rsrc     0.1 ohm   regulator output impedance plus trace
*     PTC      2.0 ohm   cold resistance of a 200 mA hold device
*     group   100   ohm  roughly 50 mA of sensors per group
*
* Network A has the PTCs. Network B is the same rail wired as one
* common node -- which is what you get if you skip them.
* ============================================================

V5A  ra 0 DC 5
Rsa  ra raila 0.1
* group A -- the faulted one. 10 mOhm is a hard short to ground.
Rpa  raila aa 2
Rfa  aa 0 10m
* groups B and C -- healthy, and the ones we care about
Rpb  raila ab 2
Rlb  ab 0 100
Rpc  raila ac 2
Rlc  ac 0 100

* ---- network B: no per-group protection ----
V5B  rb 0 DC 5
Rsb  rb railb 0.1
Rqa  railb ba 1m
Rfb  ba 0 10m
Rqb  railb bb 1m
Rlb2 bb 0 100
Rqc  railb bc 1m
Rlc2 bc 0 100

* ---- network C: stacked temperature-and-tolerance corner ----
* Same topology as network A (per-group PTC protection), but Rptc is
* the STACKED corner from the TEMPERATURE RESULT NOTE below: -40 C
* ambient (~0.8x R25, INFERRED) AND the TOLERANCE section's own -30%
* part-to-part spread, together: Rptc = 2.0 * 0.8 * 0.7 = 1.12 ohm.
* This is the check the TEMPERATURE note's own finding calls for --
* see run_sim.py's check_sensor_rail for why this is checked (not
* just the -40 C ambient case alone, which still passes).
.param Rptc=1.12
V5C  rc 0 DC 5
Rsc  rc railc 0.1
Rxa  railc xa {Rptc}
Rfx  xa 0 10m
Rxb  railc xb {Rptc}
Rlxb xb 0 100
Rxc  railc xc {Rptc}
Rlxc xc 0 100

* ---- RESOLUTION: the specified PTC, networks D and E ----
* Network C is a fail against a real requirement -- the polyfuse has
* to be the thing that clears the fault, not the 5 V regulator's own
* current limit -- so it is answered by specifying a larger device,
* the same way can_termination answers its tempco corner by
* specifying a tighter resistor.
*
* Requirement written into the BOM (docs/bom_requirements.md,
* SENSOR-PTC): one resettable PTC per sensor group, hold current
* >= 200 mA, R25 (initial cold resistance) 3.0 ohm nominal.
*
* Sizing, solved against network C's own ceiling rather than
* guessed. The fault loop is Rsrc + Rptc + Rshort in series off the
* 5 V rail, with the two healthy 100-ohm groups in parallel adding
* about 50 mA:
*     I < 3.0 A  requires  Rsrc + Rptc > 5/3 = 1.667 ohm
*     Rsrc = 0.1, so the CORNER value of Rptc must exceed 1.557 ohm
* The corner is R25 * 0.8 (cold, INFERRED, network C's own factor)
* * 0.7 (-30% part spread, the TOLERANCE section's own factor) =
* 0.56 * R25, so R25 > 2.78 ohm. 3.0 ohm is the next sensible round
* value above that, and it is the number specified.
*
*     D  the specified part at its NOMINAL 3.0 ohm -- confirms the
*        healthy-group floor and the >=0.3 A trip floor still hold
*        once the PTC is bigger, which is the thing a larger series
*        resistance could plausibly have broken.
*     E  the specified part at the SAME stacked corner network C
*        uses: 3.0 * 0.8 * 0.7 = 1.68 ohm.
.param Rspec=3.0
.param RspecCold=1.68
V5D  rd 0 DC 5
Rsd  rd raild 0.1
Rda  raild da {Rspec}
Rfd  da 0 10m
Rdb  raild db {Rspec}
Rldb db 0 100
Rdc  raild dc {Rspec}
Rldc dc 0 100

V5E  re 0 DC 5
Rse  re raile 0.1
Rea  raile ea {RspecCold}
Rfe  ea 0 10m
Reb  raile eb {RspecCold}
Rleb eb 0 100
Rec  raile ec {RspecCold}
Rlec ec 0 100

.control
op
wrdata sensor_rail.dat v(raila) v(ab) v(railb) v(bb) i(V5A) v(xb) i(V5C) v(raild) v(db) i(V5D) v(eb) i(V5E)
.endc

.end

* ------------------------------------------------------------
* RESULT NOTE -- the PTC is modelled cold, which understates it
* ------------------------------------------------------------
* A polyfuse is a thermal device: it sits at a low resistance
* until the fault current heats it, then latches into a high
* resistance until power is removed. This netlist models only the
* COLD resistance, because that is the worst case for the healthy
* groups -- it is the instant after the short, before the device
* has tripped.
*
* So the healthy-group voltage computed here is the LOW point.
* Once the device trips, the faulted branch goes to hundreds of
* ohms and the healthy groups recover to nearly the full rail.
*
* The other half of the design, not modelled here: firmware must
* notice. A tripped PTC and a dead sensor look identical from the
* ADC's side, and only the tripped one comes back after a power
* cycle. That distinction belongs in the fault manager.
*
* TOLERANCE -- the binding parameter is the PTC's cold resistance.
* This netlist picks 2.0 ohm with no part number cited ("cold
* resistance of a 200 mA hold device" -- a class description, not a
* datasheet pull). PTC cold resistance commonly spreads +/-30-50%
* part-to-part within a single hold-current bin, wider than a fixed
* resistor because it depends on the thermistor material lot, not
* just geometry. Re-ran at two corners in scratch copies, not this
* file:
*
*     PTC = 2.0 ohm (nominal)   healthy group A short = 4.661 V   PASS (>4.5)
*     PTC = 1.0 ohm (-50%)      healthy group A short = 4.496 V   FAIL
*     PTC = 1.4 ohm (-30%)      fault current          = 3.397 A  FAIL (>3.0 A)
*
* Both checks flip at a plausible low-resistance corner, at
* different PTC values -- the healthy-group floor is the more
* sensitive of the two (fails by -30% too: at 1.4 ohm ab=4.596,
* still passes; the healthy-group check needs roughly -45% to flip,
* the fault-current check needs only -30%).
*
* THE DESIGN IS INADEQUATE at this corner in the same shape as
* buck_preregulator.cir's inductor finding: 2.0 ohm was chosen as a
* class-typical figure with no datasheet min/typ/max spread behind
* it, and the healthy-group margin at nominal (4.661 V against a
* 4.5 V floor, 3.6%) is thin enough that ordinary PTC spread already
* erodes it. The fix is not a bigger PTC value picked to force a
* pass -- it is picking an actual part number and checking its
* datasheet's MINIMUM cold resistance (not typical) against both
* checks, and if no single part clears both at its worst case,
* either accepting a lower healthy-group floor than 4.5 V (see F8 in
* run_sim.py's comment on that check -- 4.5 V is itself a round
* number, not sharply derived) or adding series resistance ahead of
* the PTC so the fault-current ceiling has margin independent of the
* PTC's own spread. Not changed here for the same reason as
* buck_preregulator.cir: this value may be drawn on a schematic
* owned by a concurrently-edited file, and picking a real part
* number is an actual design decision this simulation pass should
* not make unilaterally.
*
* TEMPERATURE -- a PTC's resistance is temperature-defined by
* construction, so this is the one block on the priority list where
* ambient temperature was expected to move the verdict on its own,
* before even touching part-to-part spread. ngspice's `.temp` does
* nothing useful here -- these are plain resistors, not devices with
* a modelled tempco -- so the corners are hand-computed off the same
* topology, same as the TOLERANCE section above. Range used:
* -40/+125 C, see run_sim.py's report for provenance; multipliers are
* INFERRED from typical radial-leaded/SMD PTC resistance-temperature
* curves (no part number chosen yet, consistent with the rest of this
* file), not pulled from a specific datasheet:
*
*     -40 C  (~0.8x R25, INFERRED)   Rptc=1.6 ohm
*         raila=4.699 V  ab=4.625 V  fault current=2.919 A
*         Both checks still PASS (ab>4.5, ifault<3.0), but the
*         fault-current headroom drops from 0.635 A at nominal to
*         0.081 A -- effectively gone.
*     +125 C
*         Exceeds the standard ~85 C max-ambient rating most
*         commercial PTCs are characterised to at all. There is no
*         defensible resistance figure to extrapolate to without a
*         specific automotive-rated (125 C) part's own curve -- so
*         the honest finding at this corner is not a number, it is
*         that the class of part assumed here (a generic "200 mA
*         hold" PTC) may not have a 125 C rating in the first place.
*         That is a part-selection question, not a simulation one.
*
* What flips: nothing flips outright from ambient temperature alone
* at the -40 C end, but it removes essentially all of the margin the
* TOLERANCE section already found thin. Stacked with that section's
* own -30% part-to-part corner (cold ambient AND low-tolerance part
* together: Rptc = 2.0 x 0.8 x 0.7 = 1.12 ohm), fault current is
* 4.15 A (network C below, verified against the actual ngspice run,
* not just this note's arithmetic) -- a clear FAIL against the 3.0 A
* ceiling. This is the same finding as the TOLERANCE section,
* sharpened: a real cold-climate genset (this design's stated
* environment) will see -40 C ambient routinely, so "PTC spread alone
* might fail" becomes "PTC spread AND a cold morning will fail"
* unless a specific part's minimum cold-ambient, minimum-tolerance
* resistance is checked and found to clear 3.0 A. Not fixed here, for
* the same reason as above: it is a part-selection decision, not a
* value to tune until the check passes.
*
* ENFORCED: network C above and the "stacked -40C + -30%" check in
* run_sim.py's check_sensor_rail turn this into a checked claim
* rather than a prose note. Shape chosen: the design is inadequate at
* this corner (the 3.0 A ceiling is a real requirement -- something a
* polyfuse has to trip on -- not an arbitrary number), so the check
* FAILS and stays failing until a real PTC part is chosen with a
* datasheet minimum that clears it, or series resistance is added
* ahead of the PTC. Not fixed by changing Rptc here.
* ------------------------------------------------------------
