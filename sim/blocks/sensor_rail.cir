* ============================================================
* 5V_SENSOR -- one tracking regulator per sensor group, behind an
* overvoltage cut-off (decisions log sections 4 and 7)
* ============================================================
* Each sensor group (A, B, C) has its own TPS7B4253-Q1 tracking LDO
* whose ADJ pin follows 5V_MAIN to +/-4 mV (TI SLVSCP3D). A shorted
* group limits in ITS OWN regulator (301-520 mA), so the other groups
* and the MCU never see it. The PTCs this replaces could not do that
* against a 1 A buck, and a battery short back-fed 5V_MAIN through them.
* The trackers' own behaviour is datasheet arithmetic in run_sim.py.
* This netlist is about their shared INPUT.
*
* The trackers' IN pin is rated 45 V, and VBAT_PROT reaches 73.3 V on
* ISO 7637-2 pulse 2a in transient_clamp.cir. So all three sit behind
* one TPS48110-Q1 (TI SLUSEE5E, AEC-Q100 Grade 1) switching an
* IPD90N10S4-06 (13 mOhm modelled, twice its 25 C maximum), with hold-up
* capacitance after it on node VSNS. The cut-off must OPEN for pulse 2a
* and stay CLOSED through the 40 V suppressed load dump, which no
* hold-up capacitor could bridge.
*
* WHAT THIS BLOCK FOUND, 8 Oct 2026. The source here is pulse 2a exactly
* as transient_clamp.cir applies it, but the path to VBAT_PROT is the
* real pin-21 chain: fuse, both filter stages, TVS, reverse FET.
*
*   1. The trackers' input never gets near 45 V -- about 22 V at every
*      corner. TI's own inrush network does it: C1 (22 nF, gate to
*      ground) holds the FET's gate where it was before the pulse, so
*      the FET is a source follower and VSNS cannot rise past
*      (gate - Vth), about 12.15 + 12 - 3 V here. The OV comparator then
*      opens the FET outright once the rail passes 40.5-42.1 V. That is
*      two independent mechanisms, either of them enough.
*   2. Hold-up droop is not a concern. The follower lets VSNS rise
*      before the comparator opens it, so the hold-up starts the open
*      period above its pre-pulse level, even with all three trackers at
*      their current limit. 47 uF, the decision's value, is enough. The
*      corners below age it to 33 uF.
*   3. With L1 NOT saturated, the clamp node peaks at 76.6 V, above the
*      73.3 V transient_clamp.cir reports. That block has no filter; here
*      L1's stored energy goes into the TVS. Every part on that node is
*      100 V class. Pinned in run_sim.py rather than left as prose.
*
* THE CONTROLLER is modelled as what it does. The OV pin sees the rail
* through the divider. The comparator's rising and falling thresholds
* are the switch's hysteresis. tPD(OV_OFF) is a pure delay on the sensed
* voltage. The FET is a square-law model with the datasheet's gate
* network around it: PD (4 A) pulls the gate to the source at the end of
* the delay, and on recovery PU recharges it through the 100k / 22 nF
* inrush network. So the FET reconnects as a source follower whose gate
* C1 holds near where it was. An ideal instant switch there chattered,
* and ngspice could not follow it at the all-trackers-at-limit corner.
*
* THE 60 V/us LIMIT on the TPS48110-Q1's drain-side pins (VS, CS+, CS-)
* is met by feeding them through 100 ohm and the 22 nF the datasheet
* already requires on VS: a few V/us there. The OV divider senses the
* rail directly, so detection is not delayed.
*
* THREE COPIES of the chain, one per corner, each with its own source:
*   X1  nominal     47 uF, L1 22 uH (linear), threshold mid, 3 us delay
*   X2  top         33 uF (hold-up aged -30%), L1 saturated, HIGHEST
*                   threshold, LONGEST delay, light load -- highest VSNS
*   X3  droop       33 uF, L1 saturated, LOWEST threshold, SHORTEST
*                   delay, all three trackers at their 520 mA limit --
*                   longest open time and largest droop
* Threshold corners are the divider (340k / 10k, 0.1%) against OV rising
* 1.16-1.20 V and falling 1.10-1.13 V (SLUSEE5E):
*   rising   40.52 V min   42.08 V max
*   falling  38.38 V min   39.62 V max
* ============================================================
.model TVSJ D(Is=1e-12 N=1.6 Rs=0.50 BV=47.0 IBV=1e-3)
.subckt TVSBI a b
DA mid a TVSJ
DB mid b TVSJ
.ends TVSBI

.subckt CHAIN src prot vsns vs params: lm=22u chold=47u vtrip=41.3 vrel=39.0 tdel=3u iload=0.15
* The comparator: a hysteretic switch on a control of K - v(sensed),
* K = (vtrip+vrel)/2, so "pull-up enabled" ends at vtrip rising and
* resumes at vrel falling. ONSW is the PU path, OFFSW (the complement)
* the PD path.
.model ONSW  SW(Ron=1 Roff=1e9 Vt=0 Vh={(vtrip-vrel)/2})
.model OFFSW SW(Ron=2 Roff=1e9 Vt=0 Vh={(vtrip-vrel)/2})
* IPD90N10S4-06 as a square-law FET: 13 mOhm at Vgs 12 V (twice its
* 6.7 mOhm 25 C maximum), Vth 3 V, plus its body diode (VSNS to rail).
.model QN NMOS(LEVEL=1 VTO=3 KP=8.5 W=1 L=1)
.model DB D(Is=1e-12 N=1.0 Rs=10m)
Rsrc  src pin 2
RF101 pin f1 16m
L1    f1 l1b {lm}
RL1   l1b emi1 28m
C1    emi1 c1a 4.4u
RC1   c1a 0 2.5m
Lf    emi1 lfb 0.47u
RLf   lfb clmp 1.35m
Rf    emi1 clmp 120
C2    clmp 0 100n
Cd    clmp cdr 1u
Rd    cdr 0 2.2
XD1   0 clmp TVSBI
RQ101 clmp prot 31m
Cbuck prot 0 4.4u
Iboard prot 0 0.5
Bs    s0 0 V = 2*v(prot)
Rs0   s0 s1 50
Tdel  s1 0 s2 0 Z0=50 TD={tdel}
Rs2   s2 0 50
Bctl  ctl 0 V = {(vtrip+vrel)/2} - v(s2)
Bnot  nctl 0 V = -v(ctl)
* gate drive, SLUSEE5E Figure 8-6: PU from BST (SRC + 12 V) through
* R1 = 100k, C1 = 22 nF + R2 = 10 ohm to ground, PD straight to the gate
* (the 4 A pull-down, 2 ohm here) so turn-off ignores R1 and C1
Bbst  bst 0 V = v(vsns) + 12
Spu   bst pu ctl 0 ONSW
R1    pu g 100k
C1g   g c1r 22n
R2    c1r 0 10
Spd   g vsns nctl 0 OFFSW
Cgs   g vsns 5n
M1    prot g vsns vsns QN
DB1   vsns prot DB
RVS   prot vs 100
CVS   vs 0 22n
Chold vsns 0 {chold}
Iload vsns 0 {iload}
.ends CHAIN

* ---- pulse 2a, as transient_clamp.cir ----
Vpulse src 0 PWL(0 13.5  0.999m 13.5  1.0m 125.5  1.05m 125.5  1.0505m 13.5  3m 13.5)

X1 src p1 n1 s1 CHAIN lm=22u chold=47u vtrip=41.30 vrel=39.00 tdel=3u   iload=0.15
X2 src p2 n2 s2 CHAIN lm=1n  chold=33u vtrip=42.08 vrel=39.62 tdel=4u   iload=0.15
X3 src p3 n3 s3 CHAIN lm=1n  chold=33u vtrip=40.52 vrel=38.38 tdel=2.6u iload=1.56

.control
tran 20n 1.4m 0.9m 20n
wrdata sensor_rail.dat v(p1) v(n1) v(s1) v(p2) v(n2) v(s2) v(p3) v(n3) v(s3)
.endc

.end
