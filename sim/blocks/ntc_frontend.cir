* ============================================================
* NTC temperature front-end -- U2's unknown branch, pin 79
* ============================================================
* U2 asks whether the boost P&T combo sensor's temperature
* element is a bare NTC thermistor or a conditioned ratiometric
* output. One resistance measurement at the machine settles it
* (inspection brief task 1.3). This block designs the NTC branch
* so that answer can be acted on immediately either way.
*
* Research memo 09 found that Deep Sea Electronics drives its
* resistive temperature senders with a FIXED CURRENT and measures
* differentially -- 15 mA into a 480 ohm full scale. The obvious
* move is to copy that. This block is what happens when you check
* it against the actual sensor instead, and the answer is that it
* does not transfer.
*
* A charge-air NTC is not a VDO sender. Taking a typical
* automotive part, 2.5 kOhm at 25 C with B = 3380, over the range
* this engine's intake actually sees:
*
*     -40 C   ~59 kOhm
*      25 C    2.5 kOhm
*     150 C   ~88 Ohm
*
* That is a 670:1 span, against the 50:1 a genset sender covers.
* The two front-ends behave completely differently across it:
*
*   DIVIDER   5 V through a 2.2k pull-up. Non-linear, but the
*             non-linearity COMPRESSES the range -- output is
*             bounded by the supply rail no matter how cold it
*             gets. Resolution is best in the middle, which is
*             where the engine actually runs.
*
*   CURRENT   100 uA forced through the NTC. Linear in resistance,
*             which is the textbook advantage -- and at the cold
*             end it demands 5.9 V out of a 5 V rail. It runs out
*             of compliance before it runs out of range.
*
* The resistance is swept by a behavioural resistor whose value
* is read from a node voltage, so v(rt) = 2500 means 2500 ohms.
* ============================================================

Vrt rt 0 DC 2500

V5  v5 0 DC 5

* ---- divider front-end ----
Rpu  v5 nd 2.2k
Rnd  nd 0  R = 'v(rt)'

* ---- constant-current front-end ----
* An ideal 100 uA source: no compliance limit, deliberately. A
* real source would clip at the rail and hide the problem; this
* one lets the required voltage be read directly, which is the
* number that decides whether the topology is usable.
Ics  0  nc DC 100u
Rnc  nc 0  R = 'v(rt)'

* ---- self-heating, divider case ----
* Power in the thermistor biases its own reading. An NTC's
* dissipation constant is around 2 mW/C in still air, so a few
* milliwatts is a real error, not a rounding one.
Bpd  pd 0 V = v(nd)*v(nd)/v(rt)

.control
* 88 ohm (150 C) to 59 kOhm (-40 C), the full automotive range.
dc Vrt 88 59000 20
wrdata ntc_frontend.dat v(nd) v(nc) v(pd)
.endc

.end

* ------------------------------------------------------------
* RESULT NOTE -- the trade, and which way it falls
* ------------------------------------------------------------
* Constant current wins on:
*   - linearity (V = I*R exactly, so no lookup curve needed for
*     the front-end itself; the NTC's own curve still applies)
*   - self-heating, by four orders of magnitude
*
* The divider wins on the thing that decides it:
*   - it cannot run out of compliance, because its output is
*     bounded by the rail at both ends of the range
*
* For a 50:1 genset sender, DSE's choice is right. For a 670:1
* automotive NTC on a 5 V rail, a current small enough to stay in
* compliance at -40 C leaves almost no signal at 150 C, and the
* hot end is where charge-air temperature protection actually
* does its work.
*
* So this design keeps the pull-up divider for the NTC branch and
* takes memo 09's OTHER finding instead -- the differential input,
* which applies regardless of which topology feeds it. See the
* sensor_differential block.
*
* Self-heating is worth a second look before the value of the
* pull-up is fixed. A larger pull-up reduces dissipation but
* costs signal; the sweep here is what that trade should be
* argued from once the real sensor's dissipation constant is
* known, which is another thing task 1.3 could capture.
*
* U2 IS STILL OPEN. Everything above and below assumes the
* charge-air element is a bare NTC thermistor with the curve stated
* in the header (2.5 kOhm at 25 C, B=3380) -- one resistance
* measurement at the machine (inspection brief task 1.3) has not
* been taken. If it turns out to be a conditioned ratiometric
* output instead, this entire branch -- both front-ends, every
* check below, and the divider-vs-current conclusion itself -- does
* not apply; the input would look like sensor_ratiometric.cir's
* problem, not this one. The tolerance analysis below is therefore
* conditional on an input assumption nobody has confirmed, on top
* of being conditional on a part nobody has chosen.
* ------------------------------------------------------------
*
* ------------------------------------------------------------
* RESULT NOTE -- tolerance
* ------------------------------------------------------------
* Rpu (2.2k pull-up, +/-1%) barely moves anything: at either
* tolerance extreme the divider outputs shift by single-digit
* millivolts against checks toleranced at 30-100 mV, and the "never
* leaves the 5 V rail" guarantee is structural (Rnd/(Rpu+Rnd) < 1
* for any positive resistances) rather than dependent on the exact
* value at all. Not sensitive, not worth a re-run.
*
* The parameter that actually matters is the NTC's OWN curve --
* R25 and B -- and neither is pinned to a chosen part; "2.5 kOhm at
* 25 C with B=3380" is stated in the header as "a typical automotive
* part," not a datasheet pull. This is an arithmetic corner, not a
* SPICE one: the current-source front-end is exactly V=I*R (the
* netlist's own point), so the compliance voltage at any resistance
* is a one-line calculation, no re-run needed. Recomputed the -40 C
* endpoint across the realistic automotive NTC B-value range
* (3000-4300, R25 held at 2.5 kOhm):
*
*     B=3000  R(-40C)= 41.3 kOhm   100 uA needs  4.13 V  -- IN compliance
*     B=3380  R(-40C)= 59.0 kOhm   100 uA needs  5.90 V  -- (nominal, header's figure)
*     B=3434  R(-40C)= 62.0 kOhm   100 uA needs  6.20 V
*     B=3950  R(-40C)=100.5 kOhm   100 uA needs 10.05 V
*     B=4300  R(-40C)=139.4 kOhm   100 uA needs 13.94 V
*
* The conclusion this block draws -- that a constant-current
* front-end runs out of compliance before it runs out of range --
* gets STRONGER, not weaker, across most of the realistic B range:
* automotive charge-air/intake NTCs commonly run B=3380-4300 for
* better cold-end sensitivity, and every one of those needs MORE
* headroom than the 5.9 V already used to reject the topology, not
* less. Only an atypically low-B part (B ~3000, more common on
* cheap general-purpose thermistors than automotive-grade charge-
* air sensors) would bring the cold end back under the 5 V rail.
* So the topology decision is robust across the range a real part
* is likely to land in -- the number would have to be picked from
* the unusual end of the distribution to change the verdict, the
* same shape as load_dump's Ri countercheck (FAIL holds across the
* whole plausible range, not just at the chosen corner).
*
* What is NOT robust is the specific 5.9 V figure printed in the
* checks below -- it is only exactly right if B is exactly 3380,
* which nobody has confirmed for this part (see U2, above). Treat
* it as "several volts over compliance," not as a number accurate
* to two decimal places.
* ------------------------------------------------------------
*
* ------------------------------------------------------------
* RESULT NOTE -- temperature (ambient vs. measurand -- these are
* two different "temperature"s in this one block)
* ------------------------------------------------------------
* This block is unusual on the priority list: temperature is not an
* error source here, it is the signal. The Vrt sweep (88 ohm to
* 59 kOhm) already IS a temperature sweep -40/+150 C on the sensed
* medium (charge-air), and that range is wider than the -40/+125 C
* ECU-ambient range used everywhere else in this pass. So the
* question actually worth asking is a different one: does ECU-board
* AMBIENT temperature (acting on the front-end's own passive parts,
* not on the sensor) move anything on top of the sensor sweep that
* is already the whole point of this netlist?
*
* The only components in this front-end with any tempco of their own
* are Rpu (2.2k pull-up) and the 100 uA current source (an idealised
* SPICE source here, standing in for whatever regulates a real
* current-source IC's bias -- not simulated, so not correctable).
* The TOLERANCE section above already re-ran Rpu at +/-1% (part
* tolerance) and found single-digit-mV shifts against 30-100 mV
* checks -- not sensitive. A resistor's own -40/+125 C ambient drift
* is typically 100-200 ppm/C for a decent metal-film part (INFERRED,
* class-typical), i.e. roughly 1.65-3.3% over the full range -- the
* SAME ORDER as the +/-1% already dismissed, and the structural
* argument in the TOLERANCE section (the divider output is bounded
* by the rail regardless of Rpu's value) applies just as well to a
* temperature-driven Rpu shift as to a part-tolerance one.
*
* So: no, ambient temperature does not move this block's verdict.
* The mechanism that matters for this front-end -- the NTC's own
* resistance-temperature curve -- is not a temperature-CORNER
* question at all, it is the sweep this netlist already runs in
* full. V5's own tempco (LDO output over ambient) is covered under
* buck_preregulator.cir and mcu_pdn.cir, not re-litigated here.
* ------------------------------------------------------------
