* ============================================================
* Reverse-battery protection -- ideal diode vs Schottky
* Power chain stage 2, spec section 6
* ============================================================
* A genset battery gets jump-started by whoever is on site, and
* sooner or later someone reverses the clamps. Every ECU in this
* class has to survive that, and the only question is what it
* costs when the battery is the right way round.
*
* The obvious answer is a series Schottky. It works, and you pay
* for it on every single amp, forever. The ideal-diode controller
* answer is a P-FET held on by a controller that watches the
* polarity; the price is a controller IC, and the drop becomes
* Ron * I instead of a junction drop.
*
* This netlist puts both in the same simulation so the trade is a
* number rather than an opinion.
*
* Schottky model: a 5 A / 45 V part, roughly 0.46 V at 3 A.
* FET: 8 mOhm Ron, mid-range for a 60 V P-channel in a footprint
* this board can afford.
*
* 60 V, not the 40 V this comment said until 18 Sep 2026, and the
* correction matters more than a comment edit suggests. Spec
* section 4 fixes the stage order as
*
*     EMI filter -> fuse -> TVS -> reverse-battery FET
*
* so this FET sits DOWNSTREAM of the clamp and sees the clamped
* voltage, not the raw pulse. transient_clamp.cir measures that
* clamped voltage at ~50 V and its RESULT NOTE says in as many
* words that 60 V-class parts are what survive it. That conclusion
* was never carried the three blocks across to the part actually
* selected here, and a 40 V FET sitting on a node its neighbour
* block had already measured at 50 V is a destroyed part, not a
* tight margin.
*
* Nothing in this repo would have caught it. The switch model
* below is an ideal SPICE switch: Roff=1e9 and no breakdown
* voltage at all, so it blocks any voltage you apply forever. The
* failure mode is structurally invisible to every check here, and
* stays invisible until a real part number with a real Vds is
* chosen. Treat "60 V" as the requirement this block hands to part
* selection, not as something this block has verified.
*
* The controller is modelled as a voltage-controlled switch that
* closes on positive input polarity. That is exactly what the
* controller does, minus its turn-off delay -- which matters for
* reverse transients but not for the steady-state drop this
* block is about. See the RESULT NOTE.
* ============================================================

.model SCH  D(Is=1e-6 N=1.05 Rs=0.02 BV=45 IBV=1e-4)
.model PSW  SW(Ron=8m Roff=1e9 Vt=0.5 Vh=0.1)

* ---- forward: both paths carrying the same load current ----
Vbat bat 0 DC 13.5

* path A -- series Schottky
D1   bat sa SCH
Vsa  sa  a  0
Ia   a   0  DC 1

* path B -- ideal-diode controller + P-FET.
* F mirrors path A's current exactly, so the DC sweep loads both
* paths identically with one swept source.
S1   bat b  bat 0 PSW
Fb   b   0  Vsa 1

* ---- reverse: -14 V applied, both paths must block ----
Vrev rb 0 DC -14

D2   rb  sc SCH
Rc   sc  0  1k

S2   rb  rd rb 0 PSW
Rd   rd  0  1k

.control
* Sweep the load current across the board's whole range. 5 A is
* above anything this ECU draws; it is there to show the slope.
dc Ia 0.1 5 0.05
let d_sch = v(bat) - v(sa)
let d_fet = v(bat) - v(b)
wrdata reverse_battery_fwd.dat d_sch d_fet

* Reverse: sweep the applied voltage rather than a single operating
* point, so the blocking is shown across the range and not at one
* convenient value.
dc Vrev -14 -1 0.5
wrdata reverse_battery_rev.dat v(sc) v(rd)
.endc

.end

* ------------------------------------------------------------
* RESULT NOTE -- what this block does and does not prove
* ------------------------------------------------------------
* Proved here: the steady-state conduction loss of the two
* topologies, and that both block a reversed battery.
*
* NOT proved here: reverse-transient behaviour. A real ideal-diode
* controller takes a microsecond or so to turn the FET off, and
* during that window current flows backwards through the FET's
* body diode and channel. The controller datasheet's turn-off time
* against the board's input capacitance is what bounds that, and
* it is a datasheet question, not a SPICE question with this model.
*
* The switch model here turns off instantly, so it will always
* look perfect in reverse. Do not read the reverse numbers as a
* transient result.
*
* TOLERANCE -- the binding parameter is the FET's Ron, which sets
* the check with the least headroom, "FET drop stays under 0.3 V
* spec to 5 A" (0.040 V nominal, at 8 mOhm). Not re-run in SPICE:
* the FET's drop is exactly I*Ron with no nonlinearity in this
* model, so the corner is arithmetic. Power MOSFET Ron typically
* carries +50 to +100% headroom from 25 C to 125 C on top of unit-
* to-unit binning -- take a pessimistic +100% (worst case, hot):
* Ron = 16 mOhm, drop at 5 A = 0.080 V, still 3.75x inside the 0.3 V
* spec. Even a part binned at 3x the nominal 8 mOhm (24 mOhm, an
* unrealistically bad corner) stays under 0.3 V at 5 A (0.12 V).
* This check does not come close to being tolerance-sensitive; the
* 0.3 V spec was set with the Schottky's 0.46-0.52 V performance in
* mind; a FET would have to be an order of magnitude worse than any
* realistic part to lose that comparison.
* ------------------------------------------------------------
