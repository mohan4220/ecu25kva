* ============================================================
* Injector drive -- why the boost converter exists
* ECU pins 03/05 (high side), 73/07/29 (low side)
* ============================================================
* This is the circuit that justifies the most expensive stage on
* the board, so the justification should be measurable rather
* than asserted.
*
* A common-rail solenoid injector is an inductor with resistance.
* Current through it cannot change instantly: di/dt = V/L. The
* needle does not lift until current reaches the peak threshold,
* so the time spent getting there is time the injector is
* energised but not injecting -- pure dead time, and it sits in
* series with every injection event.
*
* Injector model, mid-range of the envelope in research memo 04:
*     L = 200 uH, R = 0.5 ohm, peak threshold 18 A
*
* Two drives are compared:
*     battery   13.5 V  -- what you get with no boost stage
*     boost    100.0 V  -- the memo 04 envelope, ~65-115 V
*
* Both are run open-loop to the point where current reaches 18 A.
* The ratio between those two times is the entire argument for
* the boost converter, and at 1500 rpm it has to be set against
* an injection duration of roughly 1-3 ms.
* ============================================================

* ---- driven from battery, no boost ----
Vbat b 0 DC 13.5
Lb   b  bm 200u
Rb   bm 0  0.5

* ---- driven from the boost rail ----
Vbst c 0 DC 100
Lc   c  cm 200u
Rc   cm 0  0.5

.control
tran 100n 800u uic
wrdata injector_boost.dat i(Vbat) i(Vbst)

* ---- temperature corners: same coil, R altered ----
* Copper's coil resistance is one physical part in both branches (see
* the header's own framing), so the same ambient tempco (~0.39%/C,
* physical constant) moves Rb and Rc together: R=0.37 ohm at -40C,
* R=0.69 ohm at +125C. `option temp` does nothing here (no junctions
* in this RL model), so this is a component-value corner, done with
* `alter` + a second/third `tran` on the SAME two branches, same
* technique as metering_unit_pwm.cir's temperature corners (and for
* the same reason: keeps the netlist's own complexity instead of
* adding parallel branches).
alter rb = 0.37
alter rc = 0.37
tran 100n 800u uic
wrdata injector_boost_cold.dat i(Vbat) i(Vbst)

alter rb = 0.69
alter rc = 0.69
tran 100n 800u uic
wrdata injector_boost_hot.dat i(Vbat) i(Vbst)
.endc

.end

* ------------------------------------------------------------
* RESULT NOTE -- this block models turn-ON only
* ------------------------------------------------------------
* Proved here: the time to reach the peak current threshold from
* a battery rail versus a boost rail, and therefore why the boost
* stage is worth its cost.
*
* NOT modelled, and it is the larger half: TURN-OFF. This netlist
* ramps current up and stops. Interrupting 18 A in 200 uH releases
* about 32 mJ, roughly seven times what the relay coil in
* relay_driver.cir stores -- and that block exists specifically to
* show what happens to a switch with nowhere to put that energy.
* The injector does this every injection event, thousands of times
* a minute. The recirculation and clamp path is a real circuit
* that this project has not yet drawn or simulated.
*
* Also not modelled:
*   - Magnetic saturation. Injector inductance falls sharply as
*     the core saturates and as the needle lifts, so a real
*     current ramp is faster than this constant-L model near the
*     top, and the 38 us figure is conservative.
*   - The needle actually moving. This is an electrical model of
*     a solenoid, with no mechanical dynamics and no back-EMF
*     from armature motion.
*   - The envelope itself is family-wide, from research memo 04,
*     not this injector's measured values. That is U5.
*
* TOLERANCE -- the binding parameter would be the injector coil's
* own L (a power inductor's worth of tolerance is not really
* applicable here since the coil IS the load, not a chosen part,
* but treat +/-20% as the stand-in for how much the "typical" 200 uH
* figure could be off for a real part). Not re-run in SPICE: the
* two times being compared (t_bat, t_bst) both use the SAME coil
* model, so for the RL step response t = (L/R)*ln(V/(V-I_th*R)),
* the L/R factor is identical in both branches and cancels exactly
* in their ratio. The "boost is faster by 11.6x" claim -- the
* entire argument this block exists to make -- is therefore
* invariant to the coil's L/R tolerance by construction, not merely
* numerically robust to it. The two individual times (439 us, 38 us)
* DO move with L/R tolerance, proportionally, but nothing here gates
* a pass/fail threshold on either one alone.
* ------------------------------------------------------------
*
* ------------------------------------------------------------
* RESULT NOTE -- temperature, and a correction to the claim above
* ------------------------------------------------------------
* THE "INVARIANT TO L/R" CLAIM ABOVE IS ONLY HALF RIGHT, and
* temperature is what exposes the half that is wrong -- caught
* re-checking the calculation rather than trusting the algebra, per
* this project's own history of exactly this kind of error. t =
* (L/R)*ln(V/(V-I_th*R)). L/R is indeed a common front-factor that
* cancels in the ratio t_bat/t_bst REGARDLESS of L or R -- that part
* is correct, and the ratio genuinely does not depend on L at all.
* But R does NOT only appear in that front factor -- it also appears
* INSIDE each log term, via I_th*R, and that occurrence does NOT
* cancel between the two branches. So the ratio is L-invariant, but
* it is NOT R-invariant, and "L/R cancels" is not the same claim as
* "R cancels."
*
* Copper's coil resistance moves with ambient the same way it does
* in metering_unit_pwm.cir and relay_driver.cir -- ~0.39%/C, giving
* R=0.37 ohm at -40 C (-26%) and R=0.69 ohm at +125 C (+38%) over
* the same physical injector coil in both branches (this is one
* part, not two, so the same ambient acts on both R's identically --
* consistent with the header's "same coil model" framing, just not
* with the conclusion drawn from it). Re-ran the actual netlist (not
* just the formula) at both R values in a scratch copy, not this
* file, to verify rather than trust the algebra:
*
*                R=0.37 (cold)   R=0.50 (27C, nom)   R=0.69 (hot)
*   t_bat (us)     367.6            439.5               732.1
*   t_bst (us)      37.3             37.8                38.5
*   ratio           9.86            11.63               19.02
*
* BOTH TEMPERATURE CORNERS FAIL THE RATIO CHECK (want 11.6+/-1.5,
* i.e. 10.1-13.1): 9.86 at cold (just under), 19.02 at hot (nearly
* 64% high). The hot corner is not a near miss -- it is the clearest
* single number in this note. It happens because R gets big enough,
* relative to Vbat=13.5 V specifically, that I_th*R starts eating a
* much larger fraction of the available voltage on the LOW-voltage
* battery branch than on the 100 V boost branch, which the boost
* branch is by design mostly immune to (I_th*R is a small fraction
* of 100 V at any of these R values). That asymmetry is exactly why
* the boost stage exists, so in one sense this reinforces the
* design's own argument -- but it also means the "11.6x faster"
* headline number is not a temperature-stable constant the way the
* TOLERANCE section above claims.
*
* THE PRACTICAL NUMBER, not just the ratio: t_bat itself grows from
* 439.5 us to 732.1 us at +125 C -- a 67% increase in injector dead
* time on the (hypothetical, no-boost) battery-only drive, which is
* the more physically meaningful figure since nothing in this design
* actually runs the injector off battery alone. On the ACTUAL boost
* rail (t_bst), the swing is tiny (37.3-38.5 us) because the 100 V
* drive is so far above I_th*R at any of these R values -- this is
* the number that matters for the real design, and it is not
* temperature-sensitive at all.
*
* ENFORCED: the `alter`-based cold/hot re-runs in the .control block
* above, and check_injector_boost in run_sim.py, turn both halves into
* checked claims, per the task's own instruction to express both. The
* "boost is faster by 11.6x" ratio check uses the SAME target/
* tolerance as the nominal check -- not invented for this pass -- and
* genuinely FAILS at both corners, which is the correction to this
* file's own "invariant by construction" claim above made executable.
* The "time to 18 A from 100 V boost" check, same target/tolerance as
* its own nominal line, PASSES at both corners -- that pass is what
* says the real (boost-driven) design is fine across temperature; it
* is the ratio's dependence on the unused battery-only comparison that
* is fragile, not the actual injector drive.
* ------------------------------------------------------------
