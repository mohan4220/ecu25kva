* ============================================================
* Discrete switch input -- ECU pins 20, 24, 71
* (audio abort, override SS, ignition)
* ============================================================
* These are ACTIVE-HIGH inputs. The OEM wires them as switched
* battery -- the red wire class in the Kirloskar diagram's legend --
* so the switch connects the pin to battery, not to ground.
*
* The prior design documents specified pull-up to 5 V with the
* switch closing to ground. That is the opposite sense, and its
* front-end cannot survive battery voltage on the pin.
*
* This circuit must:
*   1. read as logic HIGH even at a 6 V cranking dip
*   2. never exceed the MCU pin's absolute maximum at 40 V
*   3. debounce, so one contact closure is one firmware event
*   4. read as logic LOW, not floating, when the switch is open
*
* WHY THIS IS NOT A PLAIN DIVIDER. A fixed ratio cannot satisfy
* (1) and (2) together. Logic high at 6 V needs the ratio above
* 2.31/6 = 0.385; staying under 3.3 V at 40 V needs it below
* 3.3/40 = 0.0825. Those constraints do not overlap, so any single
* divider ratio fails one end of the range. The first attempt at
* this circuit used 100k/10k and failed both, which is what drove
* the topology below.
*
* So the zener sets the clamp level and the divider only biases
* into it. R5/R6 are sized so the node would sit at 3.55 V at the
* 6 V cranking dip -- already above the zener knee -- meaning the
* input is clamped to ~3.0 V across the entire 6-40 V range and
* the logic level never depends on battery voltage at all.
* R5 also limits zener current to under 1 mA at 40 V.
*
* Two copies of the network are instantiated because one source
* cannot be both DC-swept and driven by a transient waveform.
* ============================================================

* 3.0 V zener -- clamps below the MCU's VDD+0.3 absolute maximum
.model DZ3V0 D(Is=1e-14 N=1 Rs=5 BV=3.0 IBV=5e-3)

* ---- network A: DC transfer ----
Vdc swdc 0 DC 12
R5a swdc ndc 47k
R6a ndc  0   68k
C1a ndc  0   220n
D1a 0   ndc  DZ3V0

* ---- network B: transient, bouncing contact ----
* Contact chatters 5 times over 5 ms before settling at 12 V.
* This is a deliberately nasty bounce; real automotive contacts
* are usually quieter, so if the filter handles this it handles them.
Vtr swtr 0 PWL(0 0  0.999m 0  1m 12  1.4m 12  1.5m 0  2.1m 0
+ 2.2m 12  2.6m 12  2.7m 0  3.3m 0  3.4m 12  3.8m 12
+ 3.9m 0  4.4m 0  4.5m 12  20m 12)
R5b swtr ntr 47k
R6b ntr  0   68k
C1b ntr  0   220n
D1b 0    ntr DZ3V0

.control
dc Vdc 6 40 0.1
wrdata discrete_input_dc.dat v(ndc)

tran 5u 30m
wrdata discrete_input_tran.dat v(ntr) v(swtr)
.endc

.end

* ------------------------------------------------------------
* RESULT NOTE -- the fault this circuit cannot detect
* ------------------------------------------------------------
* Proved here: the level is flat across 6-40 V, stays inside the
* MCU's absolute maximum, reads a valid logic high at the 6 V
* cranking dip, and does not chatter on a bouncing contact.
*
* NOT detectable, by construction: an open wire. These are
* switched-battery inputs, so an open harness and an unpressed
* switch both read "not asserted" and nothing distinguishes them.
* Spec section 2.4 records this as accepted rather than solved --
* changing the sense would break harness compatibility, and
* detecting it otherwise needs a pull-down plus a diagnostic
* current source. It belongs in the FMEA.
*
* NOT modelled:
*   - The bounce profile is a plausible synthetic one, not a
*     measured contact. Real bounce depends on the switch, its
*     age and its mounting, and 220 nF was chosen against this
*     model rather than against the machine's actual switches.
*   - Zener tolerance and its knee. A 3.0 V zener at low current
*     is soft, so the clamped level moves with the part and with
*     temperature; the 92 mV flatness figure is for an ideal one.
*   - ESD at the connector.
*
* TOLERANCE -- the binding parameter is the zener's breakdown
* voltage. Standard low-power zeners (the 1N47xx-class part this
* would be) are commonly binned at +/-5%. Re-ran DZ3V0's BV at 2.85
* (-5%) and 3.15 (+5%) in scratch copies, not this file:
*
*     BV=2.85 V (low)   node at 6 V cranking dip = 2.718 V (want >=2.31)
*     BV=3.15 V (high)  node max over 6-40 V      = 3.104 V (want <=3.6)
*
* Both survive with wide margin -- the cranking-dip floor keeps
* 0.41 V of headroom at the low corner, the abs-max ceiling keeps
* 0.50 V at the high corner. This block's whole point is that the
* zener flattens the response against exactly this kind of part
* variation, and the tolerance run bears that out: a 10% total BV
* swing (the two corners together) moves the clamped level by
* about 0.2-0.3 V, an order of magnitude less than the pre-zener
* divider would have moved it against a 6-40 V battery swing.
* ------------------------------------------------------------
*
* ------------------------------------------------------------
* RESULT NOTE -- temperature
* ------------------------------------------------------------
* Closes the "temperature" half of the NOT MODELLED bullet above.
* Unlike the TVS parts elsewhere in this pass, a low-voltage
* (<~5 V) zener operates in the true Zener-tunnelling regime, not
* avalanche, which gives it a NEGATIVE breakdown tempco -- BV falls
* as temperature rises, opposite sign from the TVS/avalanche parts.
* INFERRED at -2 mV/C (class-typical magnitude for a 3.0 V low-power
* zener; no specific 1N47xx-family part pulled from a datasheet this
* session). Over -40/+125 C that is BV=3.13 V cold, 2.80 V hot,
* re-run on the full R5a/R6a/D1a network in a scratch copy, not this
* file (same topology and method as the BV tolerance corners above):
*
*             BV=2.80 (hot)   BV=3.0 (27 C)   BV=3.13 (cold)
*   at 6 V       2.669 V         2.863 V         2.988 V
*   at 40 V      2.755 V         2.954 V         3.084 V
*
* What flips: nothing, at either corner. Logic-high floor (>=2.31 V)
* keeps 0.36 V margin even at the hot corner where BV is lowest;
* abs-max ceiling (<=3.6 V) keeps 0.52 V even at the cold corner
* where BV is highest. Both corners stay INSIDE the +/-5% part-
* tolerance corners already run above (2.718-3.104 V) -- the
* INFERRED -2 mV/C tempco used here is a smaller swing over the full
* temperature range than a single part's binning tolerance, so this
* does not add a new risk beyond what the TOLERANCE section already
* cleared with wide margin.
* ------------------------------------------------------------
