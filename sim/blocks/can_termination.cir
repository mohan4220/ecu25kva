* ============================================================
* CAN termination -- split vs single, both channels
* ECU pins: CAN H yellow, CAN L green (spec section 2.5)
* ============================================================
* J1939 runs 250 kbit/s over a twisted pair terminated at 120 ohm
* at each end of the backbone. That much is in the standard and is
* not a design decision.
*
* What IS a design decision is whether the 120 ohms is one
* resistor or two with a capacitor to ground between them, and the
* difference does not show up in the differential impedance at all
* -- both are 120 ohm differential, which is the only number most
* schematics label.
*
* The difference is in COMMON MODE. A single 120 ohm resistor
* connects CAN H to CAN L and nothing else; common-mode noise --
* both wires swinging together against chassis, which is what a
* genset's alternator and contactors produce -- sees an open
* circuit and stays on the bus. The split version gives it a path
* to ground through the midpoint capacitor, while leaving the
* differential signal untouched because the midpoint is a virtual
* ground for differential drive.
*
* That matters more here than on a truck. Research memo 02 found
* the KG640C measures engine speed from ALTERNATOR FREQUENCY,
* sampled at 5 kHz, so this bus runs alongside 415 V three-phase
* wiring and contactor coils inside the same panel.
*
* Four measurements, driven by 1 A AC so node voltages read
* directly as ohms:
*     A  split termination, differential drive
*     A  split termination, common-mode drive
*     B  single resistor,   differential drive
*     B  single resistor,   common-mode drive
* ============================================================

* ---- A: split termination, differential drive ----
Iad1 0 ah  AC 1
Iad2 al 0  AC 1
Rah  ah mh 60
Ral  mh al 60
Csh  mh 0  4.7n
* DC path to ground so the nodes are defined. 1 MOhm is far above
* anything that affects the measurement.
Rlh  ah 0 1meg
Rll  al 0 1meg

* ---- A: split termination, common-mode drive ----
* Half an amp into each line, so 1 A of common-mode current total
* and no differential component at all.
Iac1 0 bh AC 0.5
Iac2 0 bl AC 0.5
Rbh  bh mc 60
Rbl  mc bl 60
Csc  mc 0  4.7n
Rlbh bh 0 1meg
Rlbl bl 0 1meg

* ---- B: single 120 ohm, differential drive ----
Ibd1 0 ch AC 1
Ibd2 cl 0 AC 1
Rc   ch cl 120
Rlch ch 0 1meg
Rlcl cl 0 1meg

* ---- B: single 120 ohm, common-mode drive ----
Ibc1 0 dh AC 0.5
Ibc2 0 dl AC 0.5
Rd   dh dl 120
Rldh dh 0 1meg
Rldl dl 0 1meg

* ---- temperature corner: Rah/Ral at 200 ppm/C, matched direction ----
* Same split-termination topology as network A's differential drive,
* Rah/Ral only. 200 ppm/C is ordinary standard-grade thick-film, not
* an exotic corner (see the RESULT NOTE below). Both resistors shift
* TOGETHER (matched batch, the LESS adverse of the two directions the
* TOLERANCE section already considered -- the more pessimistic
* opposite-direction case was not even needed to find something here).
* Delta = 200 ppm/C * 165 C (the full -40/+125 span, the same
* convention the RESULT NOTE's own 100 ppm/C figure uses and that
* figure is verified below to reproduce) = +3.3%, R = 60 * 1.033 =
* 61.98 ohm.
.param Rtempco=61.98
Ied1 0 eh  AC 1
Ied2 el 0  AC 1
Reh  eh mhe {Rtempco}
Rel  mhe el {Rtempco}
Cse  mhe 0  4.7n
Rleh eh 0 1meg
Rlel el 0 1meg

* ---- RESOLUTION: the specified part, network "f" ----
* The 200 ppm/C corner above is a fail against a real requirement, so
* it has to be answered by specifying a resistor rather than by
* widening the check. Requirement written into the BOM (docs/bom_
* requirements.md, CAN-TERM): Rah/Ral are 60.0 ohm THIN-FILM, initial
* tolerance +/-0.1% or better, tempco +/-50 ppm/C or better.
*
* That is an ordinary automotive-grade thin-film chip resistor class,
* not an exotic one -- the contrast with network "e" is thick-film
* (100-200 ppm/C typical) versus thin-film (25-50 ppm/C typical), a
* part-class choice with no meaningful cost or availability penalty at
* this quantity. No specific manufacturer part number is named here:
* none has been checked against a retrieved datasheet, and this repo's
* rule is that an unread figure does not become a design number. What
* the schematic carries is the REQUIREMENT -- 0.1% / 50 ppm thin-film
* -- which is a specifiable, purchasable class.
*
* Corner stacked the adverse way, both mechanisms together:
*     tempco   50 ppm/C * 165 C span   = +0.825%
*     initial  +0.1%
*     R = 60 * 1.00825 * 1.001 = 60.5555 ohm
* which is the number below. Unlike network "e" this is the WORST
* case for the specified part, not its nominal -- so passing here
* means the requirement is sufficient, not merely that it helps.
.param Rspec=60.5555
Ifd1 0 fh  AC 1
Ifd2 fl 0  AC 1
Rfh  fh mhf {Rspec}
Rfl  mhf fl {Rspec}
Csf  mhf 0  4.7n
Rlfh fh 0 1meg
Rlfl fl 0 1meg

.control
* 10 kHz to 100 MHz: from below the bit rate to the top of the
* CISPR 25 conducted band.
ac dec 100 10k 100meg
* mag() explicitly: an AC vector is complex, and wrdata writes a
* complex trace as two columns. Taking the magnitude here keeps the
* file one column per quantity and says what is meant.
let zdiff_split  = mag(v(ah) - v(al))
let zcm_split    = mag(v(bh))
let zdiff_single = mag(v(ch) - v(cl))
let zcm_single   = mag(v(dh))
let zdiff_tcorner = mag(v(eh) - v(el))
let zdiff_spec = mag(v(fh) - v(fl))
wrdata can_termination.dat zdiff_split zcm_split zdiff_single zcm_single zdiff_tcorner zdiff_spec
.endc

.end

* ------------------------------------------------------------
* RESULT NOTE -- termination is not the whole common-mode story
* ------------------------------------------------------------
* The split capacitor gives common-mode current somewhere to go.
* It does not stop it being generated, and it does nothing about
* common-mode current arriving from outside on the shield or the
* chassis.
*
* The other half of the job belongs to a common-mode choke in
* series with the pair, which -- exactly as in the emi_filter
* block -- cannot be modelled honestly as a two-terminal part. It
* needs a coupled-inductor model and a defined chassis return,
* which is a layout property this board does not have yet.
*
* One more thing this block does NOT decide: whether to fit
* termination at all. A 120 ohm terminator belongs at each END of
* the backbone, and research memo 06 noted that a single genset is
* a short enough bus that it may be one piece of wire with nodes
* at both ends. If this ECU is not an end node, fitting a
* terminator makes the bus worse. That is a U4 question -- what
* the KG640C expects -- and the board should carry the parts with
* a link so it can be either.
* ------------------------------------------------------------
*
* ------------------------------------------------------------
* RESULT NOTE -- tolerance
* ------------------------------------------------------------
* Two components, two different checks, and they do not share a
* binding parameter:
*
*   Rah/Ral (60 ohm each) set the DIFFERENTIAL impedance check --
*   Csh cancels out of that measurement by the virtual-ground
*   argument in the header, so only the resistors matter there.
*   Resistor tolerance taken at +/-1% (this repo's standard bin,
*   and the tolerance CAN termination app notes commonly call for
*   on split networks, since balance between the two halves matters
*   for EMC as much as the absolute value does). Re-ran with both
*   resistors shifted together to 60.6 ohm (+1%) in a scratch copy:
*
*       R = 60 ohm (nominal)   zdiff@250kbit  120.0 ohm  PASS (want 120+/-2)
*       R = 60.6 ohm (+1%)     zdiff@250kbit  121.2 ohm  PASS, margin 0.8/2
*
*   Passes, but the margin the check was written with (+/-2 ohm,
*   1.7%) is barely wider than what a single-direction 1% resistor
*   shift already consumes. A +5% resistor (a part someone reached
*   for without checking the tolerance) would fail this outright --
*   worth specifying 1% on the BOM line, not assuming it.
*
*   Csh/Csc (4.7 nF) sets the two COMMON-MODE checks, but not
*   equally. At 10 MHz the 60+60 ohm series path dominates over the
*   cap's ~3.4 ohm reactance, so that check barely moves with C at
*   all (+/-20% MLCC tolerance: 30.13-30.30 ohm against nominal
*   30.19, want 33+/-8 -- not sensitive). At the 250 kbit/s bit
*   rate the cap's reactance is what the "stays high" check is
*   actually measuring, and that one does move:
*
*       C = 4.7 nF (nominal)   zcm@250kbit  138.1 ohm  PASS (want >100)
*       C = 5.64 nF (+20%)     zcm@250kbit  116.3 ohm  PASS, margin down to 16%
*       C = 3.76 nF (-20%)     zcm@250kbit  171.2 ohm  PASS, more margin
*
*   +20% MLCC is the DC-bias-adverse direction is not in play here
*   (this cap sees no significant DC bias in normal operation, so
*   the -60%-near-rated-voltage figure used elsewhere does not
*   apply) -- ordinary +/-20% bin is the right one, and it still
*   clears the check, just with less than half the nominal margin.
*
* Neither check flips at a standard tolerance corner. Both go from
* comfortable to thin, which is worth recording (same shape as the
* countercheck in load_dump's own Ri finding) even though it is not
* a FAIL: a slightly worse corner than the standard bin -- a Y5V-
* class cap instead of X7R, or a 5% resistor substituted at the
* board house -- would cost this design its margin on both checks
* at once, not just one.
* ------------------------------------------------------------
*
* ------------------------------------------------------------
* RESULT NOTE -- temperature
* ------------------------------------------------------------
* The differential-impedance check's margin was already flagged
* above as "barely wider than what a single-direction 1% resistor
* shift already consumes." Ordinary resistor ambient tempco stacks
* on top of that, and this is the LESS adverse assumption from the
* TOLERANCE section reused (both resistors shifting TOGETHER, same
* direction, matched batch -- the more pessimistic opposite-
* direction case was not even needed to find something here).
*
* Re-ran Rah=Ral together at 100 ppm/C and 200 ppm/C (INFERRED,
* standard-to-decent metal/thick-film range) over the full 165 C
* span, in a scratch copy, not this file:
*
*     R=60.00 ohm (nominal)              zdiff@250kbit 119.99 ohm  PASS
*     R=60.99 ohm (100 ppm/C, +1.65%)    zdiff@250kbit 121.97 ohm  PASS, margin 0.03/2 ohm
*     R=61.98 ohm (200 ppm/C, +3.3%)     zdiff@250kbit 123.95 ohm  FAIL
*
* (60 * 1.033 = 61.98, not the 61.65 this note originally had -- a
* small arithmetic slip caught re-deriving the number for the
* enforced check below and corrected here, per this project's own
* history of exactly this kind of error. Does not change the
* verdict: still a clear FAIL either way.)
*
* AT A PLAUSIBLE, UNREMARKABLE RESISTOR TEMPCO, THIS CHECK FAILS.
* 200 ppm/C is not an exotic corner -- it is standard-grade thick-
* film, not even the cheapest available -- and 100 ppm/C already
* leaves 0.03 ohm of a 2 ohm window, which is not a margin, it is
* rounding error. This is the same shape of finding as emi_filter's
* C1: a check already flagged as thin turns out to have essentially
* no headroom left once ordinary, unremarkable component behaviour
* over temperature is actually run, rather than assumed small. The
* fix flagged in the TOLERANCE section above (spec 1% resistors on
* the BOM line) does not fully cover this -- 1% tolerance parts
* still commonly carry 100-200 ppm/C tempco ratings unless the BOM
* line specifies BOTH; this needs a tempco spec, not just a
* tolerance bin, to actually hold the margin this check assumes.
*
* ENFORCED: network "e" above and the "200 ppm/C resistor tempco"
* check in run_sim.py's check_can_termination turn this into a
* checked claim. Shape chosen: the design is inadequate at this
* corner -- 120 ohm is what J1939 specifies (the header says so
* plainly), not a round convention, so the check FAILS against the
* SAME 120+/-2 ohm target the nominal check already uses, and stays
* failing until the BOM line specifies a tempco, not just a
* tolerance bin, on Rah/Ral. Not fixed here by changing the resistor
* value.
* ------------------------------------------------------------
