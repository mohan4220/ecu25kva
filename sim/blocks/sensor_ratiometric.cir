* ============================================================
* Group A -- ratiometric sensor front-end
* ECU pins 41 (boost P), 35 (rail P), 80 (oil P), 37 (EGR pos)
* ============================================================
* These sensors are 0.5-4.5 V ratiometric: their output is a
* fraction of their own 5 V supply, so the reading means nothing
* unless the ADC reference tracks that same supply. The divider
* below scales the 5 V sensor span into the MCU's 3.3 V ADC.
*
* Three jobs:
*   1. scale 0.5-4.5 V down to fit a 3.3 V ADC
*   2. low-pass, above the sensor's own mechanical bandwidth
*      (~100 Hz) but below the switching noise the board makes
*   3. limit fault current and clamp if the harness shorts the
*      input to battery
*
* R1 is the fault-current limiter. R1/R2 set the scale. C1 sets
* the corner. D1 clamps to the 3.3 V rail.
*
* Scale: 10k/16k gives a ratio of 16/26 = 0.615, so the sensor's
* 4.5 V full scale maps to 2.77 V and its 0.5 V zero to 0.308 V.
* (That zero read 0.19 V until 19 Sep 2026, which is not what
* 0.5 * 16/26 gives. The check below has asserted 0.308 V with a
* 10 mV tolerance the whole time and has always passed, so only the
* prose was wrong -- but the prose is what a reader designing the
* ADC scaling would have used.)
* Full scale deliberately sits below the 3.3 V clamp rather than
* hard against the ADC ceiling, so the clamp can protect the pin
* on a harness fault without ever touching the signal in normal
* operation. That costs some span -- 78% of the ADC range instead
* of 83% -- and buys a front-end that cannot be damaged by 40 V
* on the sensor line.
* ============================================================

* 3.3 V zener to ground -- clamps below the MCU's 3.6 V absolute maximum.
* Sits well above the 2.77 V full-scale signal, so it never loads the
* sensor's own range; it only conducts on a harness fault.
* BAV199-Q to the 3.3 V rail and ground, since 22 Sep 2026 (was a 3.3 V
* zener to ground -- LOWV-CLAMP). Fitted to the datasheet's VF maxima,
* 0.9 V at 1 mA and 1.0 V at 10 mA: N = 1.9 through both points. The
* pin's own ESD diode is an ordinary junction (Is 1e-14) behind the 1k
* series resistor the sheet now carries -- without that resistor it
* would steal the fault current from the high-Vf BAV199.
.model DBAV D(Is=2.5e-12 N=1.9)
.model DESD D(Is=1e-14 N=1)
Vdd33 vdd33 0 DC 3.3

* ---- network A: DC transfer over the sensor's output span ----
Vsens sa 0 DC 2.5
R1a sa  na 10k
R2a na  0  16k
C1a na  0  22n
D1a na vdd33 DBAV
D2a 0  na DBAV

* ---- network B: AC response, same network ----
Vac sb 0 DC 2.5 AC 1
R1b sb  nb 10k
R2b nb  0  16k
C1b nb  0  22n
D1b nb vdd33 DBAV
D2b 0  nb DBAV

* ---- network D: rail drift, and the correction that removes it ----
* A ratiometric sensor's output IS a fraction of its own supply, so a
* reading is only meaningful against the supply it was made with.
* Spec section 4 originally answered this by having the ADC reference
* track 5V_SENSOR, which cannot be built: the S32K148's VREFH may not
* exceed its 3.3 V analog supply, and a 5 V reference is not available
* on any 3.3 V part.
*
* The buildable answer is to give the rail its own ADC channel through
* an IDENTICAL divider, and take the ratio of the two readings. The
* divider ratio then cancels algebraically:
*
*     measurand = (Vsig * k) / (Vrail * k) = Vsig / Vrail
*
* which is the fraction the sensor was reporting in the first place --
* independent of the rail voltage, and to first order independent of
* the divider's tolerance too, as long as the two dividers match.
*
* Sensor held at mid-scale (0.5 of supply) while the rail is swept
* +/-5%, which is wider than any sane regulator will drift.
Vsup  sup 0 DC 5
Bsens sd  0 V = 0.5*v(sup)
R1d   sd  nd 10k
R2d   nd  0  16k
* Rail monitor -- same divider, so the ratio cancels.
R1r   sup nr 10k
R2r   nr  0  16k
* The firmware correction, done here in one expression.
Bcorr ncorr 0 V = v(nd)/v(nr)

* ---- network C: harness short to battery, worst-case fault ----
* 40 V appears on the sensor line. R1 must limit clamp current and
* the ADC pin must stay inside its absolute maximum.
Vflt sc 0 DC 40
R1c sc  nc 10k
R2c nc  0  16k
C1c nc  0  22n
D1c nc vdd33 DBAV
D2c 0  nc DBAV
Rpc nc npc 1k
Vinj npc npx DC 0
Desd npx vdd33 DESD

.control
dc Vsens 0.5 4.5 0.01
wrdata sensor_ratio_dc.dat v(na)

ac dec 200 1 1meg
wrdata sensor_ratio_ac.dat vdb(nb)

op
wrdata sensor_ratio_fault.dat v(nc) i(Vflt) v(npc) i(Vinj)

dc Vsup 4.75 5.25 0.005
wrdata sensor_ratio_rail.dat v(nd) v(ncorr)
.endc

.end

* ------------------------------------------------------------
* RESULT NOTE -- scaling, bandwidth, fault, and the rail
* ------------------------------------------------------------
* Proved here: the sensor's span lands inside the ADC range with
* the clamp clear of it, the filter passes the sensor's own
* bandwidth while rejecting switching noise, a 40 V harness short
* is survivable, and -- network D -- that measuring the rail
* removes the ratiometric error that an assumed 5.000 V leaves.
*
* NOT modelled:
*   - GROUND OFFSET. Every network here measures against a perfect
*     ground. Pins 34 and 36 are SHARED sensor returns, and the
*     other sensor's current puts an offset on them that this
*     front-end would read as signal. Spec section 4 now specifies
*     a differential front-end for exactly those channels; see
*     sensor_differential.cir for the measurement. This block
*     remains valid for pin 08, the dedicated return.
*   - Resistor tolerance on the divider pair. Network D's
*     correction cancels it to first order only if the signal and
*     rail dividers MATCH; mismatched tolerances do not cancel,
*     and a matched resistor network is the cheap fix.
*   - ADC sampling time against the source impedance.
*   - The sensor's own error, which is usually larger than
*     anything in this front-end.
*
* TOLERANCE -- the binding parameters are R1/R2 (the divider) for
* the clamp-clearance check and R1 alone for the fault-current
* check; neither was re-run in SPICE because both are linear
* resistor networks and the result follows directly, the same way
* battery_sense.cir's own divider does (that block's re-run at 1%
* tolerance -- see its RESULT NOTE -- found the ratio moves about
* 1.4% for a corner in the same direction as this one, since it is
* the identical 10k/16k topology at a different scale here (10k/16k
* vs 10k/... note this block's absolute values differ but the
* construction is the same class of part at the same 1% tolerance).
* At +/-1%: full-scale output moves by roughly 1.4% of 2.77 V, about
* 39 mV -- against a 531 mV clamp-clearance margin that survives
* easily. Fault current is set almost entirely by R1 in series with
* a 40 V fault (the zener holds the far end near 3.3 V, a small
* fraction of the 40 V drop), so a 1% R1 tolerance moves the 3.67 mA
* figure by about the same 1%, against a 5 mA limit with 36% margin
* already in hand. Neither check is close enough to any standard
* resistor tolerance to be worth a SPICE corner run.
* ------------------------------------------------------------
*
* ------------------------------------------------------------
* RESULT NOTE -- temperature
* ------------------------------------------------------------
* R1/R2 in normal operation: same near-immune divider reasoning as
* battery_sense.cir (matched-family resistor tempco cancels in the
* ratio, dwarfed by the +/-1% corner already cleared above with wide
* margin) -- not re-run for the same reason.
*
* D1 (the fault-only zener clamp) is the parameter worth an actual
* corner, since this is the one place in the front-end where a
* single junction, not a divider, sets the answer. Confirmed
* ngspice's `option temp=` barely moves this DZ3V3 model on its own
* (no TBV1 set, same limitation as the TVSJ models elsewhere), so BV
* is varied explicitly, network C only (the 40 V harness-short fault
* network), in a scratch copy, not this file. Unlike the TVS/
* avalanche parts, a low-voltage (<5 V) zener operates in the true
* Zener regime, which has a NEGATIVE breakdown tempco -- BV falls as
* temperature rises. INFERRED at -2 mV/C (class-typical magnitude,
* no specific part datasheet pulled), giving BV=3.434 V cold
* (-40 C), BV=3.104 V hot (+125 C):
*
*            BV=3.104 (hot)   BV=3.3 (27 C, nominal)   BV=3.434 (cold)
*   node        3.112 V          3.308 V                  3.442 V
*   ifault      3.689 mA         3.669 mA                 3.656 mA
*
* What flips: nothing. Node stays under the 3.6 V abs-max ceiling at
* both corners -- margin shrinks from 0.292 V nominal to 0.158 V at
* the cold corner (higher BV pushes the clamp level up) and widens
* to 0.488 V hot. Fault current barely moves (dominated by R1, not
* the zener drop) and stays far inside the 5 mA limit throughout.
* This result is reused verbatim by cam_frontend.cir, which contains
* the numerically identical fault network.
* ------------------------------------------------------------
