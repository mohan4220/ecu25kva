* ============================================================
* Relay driver -- ECU pins 50 (main relay), 69 (buzzer relay)
* ============================================================
* Low-side N-FET switching a relay coil, with a flyback diode.
*
* The flyback diode is the whole point. A relay coil is an
* inductor; interrupting its current generates V = -L*di/dt
* across it, and with a fast FET turn-off that spike reaches
* hundreds of volts -- far past the FET's drain-source rating.
* The diode gives the collapsing field a path to circulate in.
*
* This netlist runs the same coil twice, with and without the
* diode, so the spike is visible as a number rather than a
* warning in a datasheet.
*
* Coil model: a typical automotive 12 V relay, ~160 ohm, 1.2 H,
* drawing ~85 mA.
* ============================================================

.model DFLY  D(Is=1e-14 N=1 Rs=0.05 BV=600 IBV=1e-6)
.model NSW   SW(Ron=0.05 Roff=1e9 Vt=2.5 Vh=0.2)

Vbat  bat 0 DC 13.5

* Gate drive: on at 1 ms, off at 6 ms
Vg g 0 PWL(0 0  0.999m 0  1m 5  6m 5  6.0001m 0  12m 0)

* ---- with flyback diode ----
L1  bat da 1.2
R1  da  db 160
S1  db  0  g 0 NSW
D1  db  bat DFLY

* ---- without flyback diode, for comparison ----
* A 10 Meg resistor stands in for the leakage that would otherwise
* leave this node floating; without it the node has no DC path and
* the simulation cannot find an operating point.
L2  bat ea 1.2
R2  ea  eb 160
S2  eb  0  g 0 NSW
Rleak eb 0 10meg

.control
tran 1u 12m uic
wrdata relay_driver.dat v(db) v(eb)
.endc

.end

* ------------------------------------------------------------
* RESULT NOTE -- read the "without diode" number carefully
* ------------------------------------------------------------
* The simulated peak without the flyback diode is absurd (hundreds
* of kV). That is the ideal-switch model being taken literally: a
* perfect switch opening instantly across an inductor implies an
* unbounded voltage.
*
* A real MOSFET does not reach that. It avalanches at its
* drain-source breakdown (typically 40-100 V for a part in this
* role) and dissipates the coil's stored energy as heat in the
* die -- repeatedly, once per relay operation, until it fails.
*
* So the honest reading is not "402 kV" but "the coil's energy has
* nowhere to go except through the FET." The diode's job is to
* give it somewhere else. The magnitude is a model artifact; the
* conclusion is not.
*
* TOLERANCE -- the check that matters here is the WITH-diode drain
* peak, gated under 15 V (14.274 V nominal, 4.8% margin). The
* binding parameter is not really a component tolerance in the
* usual sense -- it is Vbat itself. This netlist fixes it at 13.5 V
* "nominal," but the relay only operates while the engine is
* running, which is also when the alternator is charging the
* battery at 14.0-14.4 V, not sitting at rest. Re-ran with Vbat =
* 14.4 V (a common alternator float-charge setpoint) in a scratch
* copy, not this file:
*
*     Vbat = 13.5 V (this file's assumption)   drain peak = 14.274 V   PASS
*     Vbat = 14.4 V (alternator charging)      drain peak = 15.177 V   FAIL
*
* The offset above Vbat (drain peak - Vbat) is ~0.77-0.78 V in both
* cases -- the flyback diode's forward drop under the coil's
* collapsing current, roughly constant -- so this is genuinely a
* Vbat effect, not a diode-tolerance one. FLAGGED, not fixed: this
* is a "design inadequate" case in the sense that the check's own
* premise (13.5 V) does not cover the condition (charging voltage)
* under which the relay actually operates, but no FET part number
* is chosen here and the 15 V threshold itself is not derived from
* one either -- there is no stated Vds rating this compares against,
* the same unsourced-number problem the 2026-09-18 review's F7
* found in transient_clamp.cir's 55 V line. Most N-channel parts
* used in this role are rated 20-60 V, so 15.2 V is very unlikely to
* be a real hardware problem -- but the CHECK as written should
* either be run at a charging-voltage Vbat, or the 15 V line should
* cite the actual part's Vds rating instead of a round number. Left
* unresolved rather than silently loosened or a value changed here.
* ------------------------------------------------------------
*
* ------------------------------------------------------------
* RESULT NOTE -- temperature
* ------------------------------------------------------------
* D1's forward conduction drop (what sets drain peak = Vbat + Vf,
* per the TOLERANCE section above) is a real junction effect --
* unlike the TVS breakdown parameters elsewhere, `option temp=`
* moves plain forward conduction correctly (confirmed on this exact
* model). Re-ran the with-diode network at -40/+125 C, both Vbat
* cases already in the file, in a scratch copy, not this file:
*
*                    Vbat=13.5 V (nominal)   Vbat=14.4 V (charging)
*   27 C  (this file)     14.274 V PASS           15.177 V FAIL
*   -40 C                 14.372 V PASS           15.276 V FAIL
*   +125 C                14.124 V PASS           15.028 V FAIL
*
* What flips: nothing. Temperature moves the drain peak by
* +/-0.10-0.15 V, an order of magnitude smaller than the ~0.9 V the
* Vbat question above already accounts for. The 13.5 V case stays a
* clean PASS at both temperature extremes; the 14.4 V case, already
* FAILING at 27 C for the Vbat reason already flagged, stays FAILING
* at both extremes too -- temperature does not create or cure that
* failure, it just nudges it by a few tenths of a volt either way.
* The Vbat question remains the thing to resolve, not this one.
* ------------------------------------------------------------
