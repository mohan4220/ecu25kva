* ============================================================
* Transient clamp -- ISO 7637-2 pulse 2a into the battery input
* ============================================================
* This is the circuit that decides whether the board survives the
* electrical environment, so it is worth simulating rather than
* assuming.
*
* Pulse 2a models a sudden interruption of current in a device
* sharing the harness with this ECU. Per the severity table in
* research memo 06 (ISO 7637-2:2011, Level IV, 12 V system):
*
*     amplitude        +112 V
*     source impedance   2 ohm
*     pulse width        0.05 ms
*
* The clamp must hold the buck converter's input pin below its
* absolute maximum -- the LM5164 is a 100 V part, but the design
* target from the earlier artifacts is to stay under 42 V so that
* cheaper 60 V-class parts remain an option.
*
* D1 is an SMBJ33CA-class bidirectional TVS: 33 V working, ~36.7 V
* breakdown, ~53.3 V clamping at full rated pulse current.
* C1 is the bulk input capacitance that the TVS works alongside --
* it matters, because charge dumped into it is charge the TVS does
* not have to absorb.
* ============================================================

* TVS: breakdown 36.7 V, low dynamic resistance above the knee
* ---- SMBJ33CA, modelled as the bidirectional part it actually is ----
* The "CA" suffix means bidirectional: two avalanche junctions in
* anti-series inside one package. Until 19 Sep 2026 both this block and
* load_dump.cir modelled it as a SINGLE diode, which is correct for a
* positive transient and silently wrong for anything negative -- one
* junction conducts forward at 0.7 V in reverse polarity, so the model
* would have answered a reverse-battery or negative-pulse question
* confidently and wrongly rather than failing visibly.
*
* Split so the WHOLE device still matches the datasheet it stood for,
* not so each junction does: in avalanche one junction breaks down and
* the other is forward-biased, so BV_total = 36.0 + Vf(0.7) = 36.7 V,
* and the two Rs of 0.175 sum to the 0.35 ohm the single-diode model
* used. Positive-direction behaviour is therefore unchanged by
* construction -- the checks below confirm it rather than assume it.
.model TVSJ D(Is=1e-12 N=1.6 Rs=0.175 BV=36.0 IBV=1e-3)
.subckt TVSBI a b
* common anode at mid: whichever terminal is positive sees one
* junction in avalanche and one forward, in either direction
DA mid a TVSJ
DB mid b TVSJ
.ends TVSBI

* Pulse 2a: 112 V peak, 2 ohm source, 50 us wide, fast rise
Vpulse src 0 PWL(0 13.5  0.999m 13.5  1.0m 125.5  1.05m 125.5  1.0505m 13.5  3m 13.5)
Rsrc src bat 2

XD1 0  bat TVSBI
C1  bat 0   10u
Rload bat 0 50

.control
tran 100n 2m
wrdata transient_clamp.dat v(bat) v(src)
.endc

.end

* (Clamp figures updated 19 Sep 2026: the bidirectional TVS model
* clamps 0.7-1.0% higher than the single diode it replaced, because
* the second junction's forward drop is not the 0.7 V assumed at
* the low test current -- at the ~37 A this pulse actually runs it
* is higher. The split's construction is right; the constant-Vf
* shorthand used to justify it was not.)
* ------------------------------------------------------------
* RESULT NOTE
* ------------------------------------------------------------
* Simulated clamp voltage under this pulse is ~50 V, not the
* "under 42 V" the earlier design artifacts asked for. That
* target cannot be met by an SMBJ33CA and was never derivable
* from a datasheet: the real SMBJ33CA is specified at 53.3 V
* clamping at its rated pulse current, so ~50 V here is the part
* behaving correctly, not the circuit failing.
*
* What actually constrains the design:
*   - LM5164 input rating is 100 V, so 50 V leaves 2x margin
*   - 60 V-class alternatives also survive 50 V
*
* The 42 V figure should be dropped from the spec rather than
* chased with a lower-voltage TVS, which would clamp during a
* legitimate suppressed load dump and have to absorb its energy.
*
* TOLERANCE -- the one parameter this verdict could plausibly move
* on is C1, the bulk input capacitance, since charge dumped into it
* is charge the TVS does not have to clamp. Re-ran with C1 swept to
* 0 (effectively removed) in a scratch copy, not this file:
*
*     C1 = 10 uF (nominal)  ->  vmax = 50.499 V
*     C1 = 0 (removed)      ->  vmax = 50.499 V
*
* Identical to three decimal places. The TVS's own 0.35 ohm dynamic
* resistance dominates the clamp against this 2 ohm/50 us source
* pulse; C1 is not doing the clamping work at all here (it matters
* for load_dump.cir's much longer pulse, not this one). So this
* block's verdict does not depend on C1's tolerance -- there is
* nothing to corner-test. The 55 V/60 V/100 V margin checks above
* would only move if the TVS's own breakdown voltage or dynamic
* resistance moved (temperature, part-to-part spread), which is
* F11 in the 2026-09-18 review -- out of scope here, not modelled.
*
* TEMPERATURE -- F11, closed. Checked first whether ngspice's `option
* temp=` moves this model at all: it does, but only ~0.48% over the
* full -40/+125 C span (via IS/Rs implicit temperature terms), because
* this TVSJ model has no TBV1/TBV2 set -- BV itself is not tied to
* temperature in this netlist. That is far smaller than a real TVS's
* quoted breakdown tempco, so `.temp` alone would understate the
* effect; BV is varied explicitly instead, same treatment as the C1
* sweep above, in scratch copies, not this file. Range -40/+125 C
* (see run_sim.py's report for provenance). Tempco figure is INFERRED
* -- class-typical for small SMB-package TVS arrays, commonly quoted
* in the 0.06-0.14%/C range; SMBJ33CA's own datasheet tempco was not
* pulled in this session. BV(T) = BV25 * (1 + tempco*(T-25)):
*
*     27 C  (BV=36.0, nominal)              vmax = 50.50 V
*     -40 C (0.1%/C, BV=33.66)              vmax = 48.52 V
*     +125 C (0.1%/C, BV=39.60)             vmax = 53.54 V
*     +125 C (0.14%/C, aggressive INFERRED, BV=41.04)  vmax = 54.76 V
*
* What flips: nothing, at either corner, for the checks that actually
* constrain this design (60 V-class parts: 5+ V margin even at the
* aggressive hot corner; LM5164's 100 V rating: >45 V margin). But the
* netlist's own self-described-as-unsourced 55.0 V trip-wire check
* (see the comment on that check in run_sim.py) goes from a 4.5 V
* margin at nominal to a 0.24 V margin at the aggressive hot corner --
* it does not fail, but it is no longer meaningfully passing either;
* a tempco at the high end of the class-typical range, or a colder
* ambient extreme, could flip it. That check was already flagged as
* not tied to any datasheet or standard; this is one more reason not
* to read it as a spec. The checks that matter are not close.
* ------------------------------------------------------------
