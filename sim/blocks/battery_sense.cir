* ============================================================
* Battery voltage sense divider  -- ECU pins 04 / 06
* ============================================================
* Scales the 6-40 V battery rail into the MCU's ADC input range.
*
* The MCU is an S32K148 running its analog supply at 3.3 V, so the
* ADC input must never exceed 3.3 V even at the top of the input
* range. Spec section 4 Group H inherited 75k/10k from an earlier
* artifact that assumed a 5 V ADC; this file tests both so the
* difference is visible rather than argued about.
*
* Two independent channels exist (pins 04 and 06, one per fused
* rail). They are identical, so only one is modelled.
* ============================================================

Vbat bat 0 DC 12

* --- inherited divider, sized for a 5 V ADC: 10/85 ---
R1 bat old 75k
R2 old 0  10k

* --- corrected divider, sized for a 3.3 V ADC: 10/130 ---
R3 bat new 120k
R4 new 0   10k

.control
* Sweep the full specified input range: cranking dip to clamped load dump
dc Vbat 6 40 0.1
wrdata battery_sense.dat v(old) v(new)
.endc

.end

* ------------------------------------------------------------
* RESULT NOTE -- what a divider cannot tell you
* ------------------------------------------------------------
* Proved here: the scaling is right, it stays inside the ADC's
* range across the whole 6-40 V input band, and it is linear.
*
* The linearity check deserves a caveat: a resistive divider is
* linear by construction, so that check cannot fail for a correct
* netlist. It is there to catch a WRONG TOPOLOGY -- someone
* substituting a zener or a clamp into this position later -- not
* to validate the values. Read it as a regression guard, not as
* evidence.
*
* NOT modelled:
*   - Resistor tolerance. At 1% on each leg the ratio moves about
*     1.4%, which at 40 V is 43 mV. That eats a fifth of the
*     231 mV of headroom below the rail, and it should be checked
*     against the real parts before the divider is called safe.
*   - Temperature coefficient, for the same reason.
*   - ADC input impedance. The 10 k lower leg is a high source
*     impedance for a SAR ADC's sampling capacitor; sampling time
*     has to be set for it, or the reading will be low. That is a
*     firmware and datasheet question, not a SPICE one.
*   - What these pins actually feed. U7 asks whether 04 and 06 are
*     sense-only or also carry load current; if they carry load,
*     this front-end is right but the pin's current rating is not
*     yet established.
*
* TOLERANCE -- the binding parameter is R3/R4's ratio, since that
* is the only thing standing between the corrected divider and the
* 3.3 V rail. At standard 1% resistors, worst case for MAXIMUM
* output is R3 low / R4 high: R3=118.8k, R4=10.1k. Re-ran with
* those values in a scratch copy, not this file:
*
*     nominal (120k/10k)      new.max() = 3.069 V, headroom 0.231 V
*     corner (118.8k/10.1k)   new.max() = 3.126 V, headroom 0.174 V
*
* Headroom shrinks by about a quarter but stays comfortably
* positive -- survives. This matches the "eats a fifth of the
* headroom" figure already estimated (untested) in the NOT MODELLED
* list above; the actual run confirms it and shows it does not flip
* the check. Temperature coefficient was not tested separately: a
* standard metal-film part's TC (typically ~100 ppm/C) moves the
* ratio by far less than 1% tolerance already does over the
* -40..125 C range, so it is dominated by the tolerance case above,
* not an independent corner worth its own run.
* ------------------------------------------------------------
