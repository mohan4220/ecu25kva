* ============================================================
* 3V3_MCU power distribution network -- decoupling impedance
* Power chain stages 6 and 7, spec section 6
* ============================================================
* The S32K148 runs to 112 MHz in HSRUN. Every time its core
* switches, it demands current faster than the regulator can
* respond, and the decoupling network is what supplies it in the
* meantime. The design question is not "how much capacitance"
* but "what impedance, at which frequency".
*
* Target impedance is the honest way to state it:
*     Z_target = allowed ripple / transient current step
* Allow 50 mV on a 3.3 V rail (about 1.5%) against a 0.5 A step,
* and the network has to stay under 100 mOhm everywhere the MCU
* can excite it.
*
* This is an AC analysis driven by a 1 A current source, so the
* voltage at the node reads directly as impedance in ohms.
*
* Three contributors, each dominant over its own decade:
*   LDO      low impedance at DC, rising with frequency once it
*            runs out of loop gain -- modelled as R + L. 0.15 uH
*            corresponds to about 1 ohm at 1 MHz, typical for a
*            small LDO once its loop has run out.
*   bulk     47 uF, ESR 50 mOhm, ESL 2 nH
*   ceramic  10 x 100 nF placed at the pins: 1 uF total,
*            ESR 30/10 = 3 mOhm, ESL 0.8/10 = 0.08 nH
*
* Paralleling ten small capacitors instead of fitting one 1 uF
* part is the entire trick: capacitance adds, but ESR and ESL
* DIVIDE. The inductance is what the MCU actually feels at
* hundreds of MHz, and it is set by how many packages and vias
* share the current, not by the capacitance printed on them.
*
* THE BULK CAPACITOR IS SIZED BY A RESONANCE, NOT BY CHARGE.
* The first version of this block used 10 uF with 20 mOhm ESR and
* peaked at 3.4 ohms around 48 kHz -- thirty times the target, and
* nowhere near the bulk/ceramic anti-resonance it was sized for.
* That peak is the regulator's own output inductance resonating
* with the bulk capacitance, and the two things that fix it are
* MORE bulk capacitance (moving the resonance down) and MORE bulk
* ESR (damping it). A lossy bulk part does both, which is why a
* plain aluminium or tantalum part beats a ceramic here. Fitting
* a low-ESR ceramic as the bulk would make this worse.
*
* The bulk is 150 uF, raised from 47 uF on 18 Sep 2026 after the
* tolerance pass showed 47 uF cleared the target only at the
* nominal value of a parameter nobody has pinned. See the
* tolerance RESULT NOTE for the sweep that chose 150.
* ============================================================

Iac n 0 AC 1

* ---- LDO: flat to its loop bandwidth, inductive above ----
Rldo n l1 0.01
Lldo l1 0 0.15u

* ---- bulk capacitor ----
Cb  n  b1 150u
Rb  b1 b2 50m
Lb  b2 0  2n

* ---- ten ceramics in parallel, lumped ----
Cc  n  c1 1u
Rc  c1 c2 3m
Lc  c2 0  0.08n

* ---- comparison: the same 1 uF as ONE package ----
* Same capacitance, one part's worth of ESR and ESL. This branch
* is on its own node so it can be plotted against the ten-part
* network and the difference attributed to the parasitics alone.
Iac2 m 0 AC 1
Rldo2 m m1 0.01
Lldo2 m1 0 0.15u
Cb2  m  p1 150u
Rb2  p1 p2 50m
Lb2  p2 0  2n
Cs   m  s1 1u
Rs   s1 s2 30m
Ls   s2 0  0.8n

.control
ac dec 100 1k 100meg
wrdata mcu_pdn.dat vm(n) vm(m)
.endc

.end

* ------------------------------------------------------------
* RESULT NOTE -- what a lumped PDN model leaves out
* ------------------------------------------------------------
* This is a lumped model. It has no planes, no via inductance and
* no spreading inductance, so it is optimistic above roughly
* 100 MHz where those dominate and where the capacitors have
* stopped being capacitors.
*
* What it is good for is the decade either side of the
* anti-resonance between the bulk and ceramic banks -- the peak
* in the plotted impedance. That peak is real, it is where a PDN
* actually fails, and its height is set by the ESRs, which this
* model does have. Damping it is what the bulk capacitor's ESR is
* FOR; a very low-ESR bulk part makes this peak worse, not better,
* which is the counter-intuitive result worth carrying into
* layout.
*
* Plane capacitance and via inductance are a post-layout question
* for a field solver, not for SPICE.
*
* The sweep therefore STOPS at 100 MHz, and that limit is load
* bearing rather than cosmetic. An earlier version swept to 1 GHz
* and the checks dutifully reported a 483 mOhm "peak" -- which was
* not a resonance at all, just ESL*omega at the last point of the
* sweep, read out of a model that stopped being true a decade
* earlier. A check that reads a model outside its validity will
* always find something, and it will always be wrong.
* ------------------------------------------------------------
*
* ------------------------------------------------------------
* RESULT NOTE -- tolerance, and the fix that was applied
* ------------------------------------------------------------
* The binding parameter is Lldo, the LDO's modelled output
* inductance. Unlike the bulk and ceramic parts, it is not a
* catalog value with a tolerance bin -- it is this block's
* behavioural stand-in for "how inductive does a small LDO's output
* look once its loop runs out of gain", and no specific LDO part
* has been cited to pin it. INFERRED, both nominal and corner.
*
* At the original 47 uF bulk, the block cleared its target only at
* the nominal value of that unpinned parameter:
*
*     Lldo 0.15 uH (nominal)  ->  peak  74.2 mOhm at   67.6 kHz  PASS
*     Lldo 0.35 uH            ->  peak 145.9 mOhm at   39.8 kHz  FAIL
*
* A 26% margin evaporating under a plausible restatement of a
* number nobody has measured is not a margin. The 100 mOhm target
* is not the arbitrary kind that could be argued away either: it is
* 50 mV allowed ripple / 0.5 A transient step, derived rather than
* rounded.
*
* THE FIX, APPLIED: bulk capacitance 47 uF -> 150 uF. This is the
* same lever this block already pulled once -- the first version
* (10 uF, 20 mOhm) peaked at 3.4 ohm and was cured by more bulk
* capacitance and more bulk ESR. Sweeping both parameters together:
*
*            Cb= 47 uF   Cb=100 uF   Cb=150 uF
*   Lldo 0.15u    74.2       60.1        60.4   mOhm
*   Lldo 0.35u   145.9       79.3        60.6   mOhm
*   Lldo 0.50u      --      104.3        76.6   mOhm
*   Lldo 1.00u      --      188.3       132.1   mOhm
*
* 100 uF would have cleared the 0.35 uH corner and then failed at
* 0.5 uH, which for an unpinned parameter is buying back the same
* problem one step further out. 150 uF holds to 0.5 uH.
*
* 150 uF is also where the sweep stops paying. At 47 uF the tallest
* peak is the regulator's inductance against the bulk, in the tens
* of kHz. By 150 uF that resonance has dropped and damped far
* enough that a different peak is tallest -- the bulk/ceramic
* anti-resonance at 2.63 MHz, floored near 60 mOhm. More bulk does
* not move that one, so beyond 150 uF the block buys nothing.
*
* That handover is the real result, and the checks now assert it:
* the surviving peak does not depend on Lldo at all. The block's
* verdict has stopped resting on the parameter nobody has pinned.
*
* Still worth doing: replace the INFERRED Lldo with a pulled Zout
* curve once an actual LDO is chosen. The difference is that the
* answer no longer changes the design if it comes back unfavourable
* -- at 150 uF, Lldo would have to reach about 1 uH to threaten the
* target, which is far outside this class of part.
* ------------------------------------------------------------
