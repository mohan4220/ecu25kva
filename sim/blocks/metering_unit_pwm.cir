* ============================================================
* Fuel metering unit driver -- ECU pin 88, low-side PWM
* ============================================================
* The metering unit sets rail pressure by throttling fuel into the
* high-pressure pump. It is a proportional solenoid, not a valve
* that is either open or shut, and what positions it is the
* AVERAGE current through the coil. The ECU's rail pressure loop
* closes onto the rail pressure sensor (pins 32/35/08); its output is
* a current command, which the firmware's inner loop turns into this
* PWM duty (decisions log 23).
*
* Spec section 2.2 corrected an earlier reading here: this is a
* single low-side PWM output on pin 88, not an H-bridge. The
* metering unit's other pin sits on fused battery (20 A, fuse
* 8F1), so the ECU switches the return path only.
*
* COIL (18 Nov 2026, decisions log 25): the owner measured 2.5-5 ohm
* on the set's metering unit. Before that this file assumed 10 ohm,
* a class guess. Nominal here is the middle, 3.75 ohm. At 13.5 V a
* nominal coil draws 3.6 A fully on, much more than it needs.
* The inductance is still unmeasured: 11.25 mH keeps the 3 ms time
* constant the firmware and the engine model were tuned to.
*
* THE OPERATING POINT: 0.675 A, a point low in the valve's range.
* Bosch's data for its metering units (the set's is 0 928 400 820)
* puts idle at 1.38-1.43 A and the maximum, taken as closed
* (MU_I_FULL), at 1.8 A (decisions log 27). Until 22 Nov this file
* called 0.675 A half of an assumed 1.35 A. At 3.75 ohm the duty for
* it is 0.675 * 3.75 / 13.5 = 18.75 %.
*
* THE DESIGN CHOICE IS THE PWM FREQUENCY, and it is not simply
* "as high as possible". Ripple current is
*
*     dI = V * D * (1-D) * T / L
*
* so it falls as frequency rises. But a proportional solenoid has
* static friction, and a valve held at a perfectly constant
* current sticks and then jumps. Deliberate ripple -- dither --
* keeps it moving and makes the response smooth and repeatable.
* Too little dither and the valve is sticky; too much and the
* ripple modulates rail pressure directly.
*
* Three frequencies are run at the same duty so the trade is
* visible as numbers:
*
*     100 Hz   period 10 ms, comparable to the coil's own 3 ms
*     1 kHz    period 1 ms
*     10 kHz   period 100 us, ripple essentially gone
*
* All three must produce the SAME average current, because that
* is the control law the pressure loop depends on. If average
* current moved with frequency, the loop's gain would depend on a
* constant nobody thinks about.
* ============================================================

.model NSW  SW(Ron=25m Roff=1e9 Vt=2.5 Vh=0.2)
* Freewheel diode. Interrupting the coil current with no path
* produces a spike that destroys the switch. Here it does a second
* job -- it sets how fast the current decays during the off-time,
* and so sets the ripple.
.model DFW  D(Is=1e-12 N=1.05 Rs=20m BV=200 IBV=1e-6)

Vbat bat 0 DC 13.5

* ---- 100 Hz, 18.75 % ----
Vg1 g1 0 PULSE(0 5 0 1u 1u 1.875m 10m)
L1  bat a1 11.25m
R1  a1  b1 3.75
Vs1 b1  c1 0
S1  c1  0  g1 0 NSW
D1  c1  bat DFW

* ---- 1 kHz ----
Vg2 g2 0 PULSE(0 5 0 1u 1u 187.5u 1m)
L2  bat a2 11.25m
R2  a2  b2 3.75
Vs2 b2  c2 0
S2  c2  0  g2 0 NSW
D2  c2  bat DFW

* ---- 10 kHz ----
Vg3 g3 0 PULSE(0 5 0 100n 100n 18.75u 100u)
L3  bat a3 11.25m
R3  a3  b3 3.75
Vs3 b3  c3 0
S3  c3  0  g3 0 NSW
D3  c3  bat DFW

* ============================================================
* RESOLUTION -- branch 4: closed-loop (hysteretic) current control
* ============================================================
* Branches 1-3 are OPEN LOOP: a fixed duty into a coil whose
* resistance spreads 2.5-5 ohm part to part and moves with copper's
* 0.38 %/C on top. The corners this design has to survive are the
* lowest coil cold and the highest coil hot:
*
*     2.5 ohm at -40 C  -> 1.85 ohm
*     5 ohm at +125 C   -> 6.91 ohm
*
* At a fixed 18.75 % duty that is roughly 1.36 A and 0.37 A against
* a 0.675 A target: twice and half. No better part fixes it; the
* driver has to regulate CURRENT, not duty. That is what production
* metering unit (MPROP) drivers do, and what the firmware does
* (actuate.c mu_step on ISNS_MU).
*
* Modelled as a hysteretic (bang-bang) regulator, the simplest form
* of current control and the one that needs no compensation network:
* the switch closes while sensed current is below the setpoint and
* opens above it. Bctl4 is the comparator -- 2.5 V is NSW's own
* threshold, and the gain of 3 against the model's +/-0.2 V
* hysteresis sets the regulation band at 0.4/3 = 0.133 A.
*
* Rsh4 is the sense element, R501, 50 mOhm: 33.75 mV at 0.675 A into
* the INA181 (gain 20, 1 V/A), so ISNS_MU reads up to 3.3 A. With the
* low-resistance coil the current can now exceed that: up to
* 13.5/1.85 = 7.3 A (8.6 A at 16 V) at full duty. In normal running
* the loop holds the current near its command, and the firmware stops
* trusting the measurement when it reads open load or over current.
* Then it falls back to feedforward, where the cold low coil is the
* worst case (decisions log 25).
*
* The claim this branch makes, checked in run_sim.py at all three
* corners: the mean current holds the 0.675 A setpoint within
* +/-0.09 A. Headroom makes that possible: at the hot corner the coil
* can still draw 13.5/6.91 = 1.95 A at 100 % duty, almost three times
* the setpoint, and 8 % over the 1.8 A that closes the valve. Below
* 12.4 V the hot coil cannot close it.
* ============================================================
Bctl4 ctl4 0 V = 2.5 + 3*(0.675 - abs(i(Vs4)))
L4   bat a4 11.25m
R4   a4  b4 3.75
Rsh4 b4  s4 50m
Vs4  s4  c4 0
S4   c4  0  ctl4 0 NSW
D4   c4  bat DFW

.control
* 60 ms is twenty coil time constants, so all three are in steady
* state well before the measurement window at the end.
tran 5u 60m uic
wrdata metering_unit_pwm.dat i(Vs1) i(Vs2) i(Vs3) i(Vs4)

* ---- corners: the same branches, R altered ----
* Done with `alter` + another `tran`, not more parallel branches:
* six-plus switched RL branches off one ideal source made ngspice's
* timestep collapse (a convergence limit of this topology).
* Cold: the lowest coil, 2.5 ohm, at -40 C (x0.739).
alter r1 = 1.85
alter r2 = 1.85
alter r3 = 1.85
alter r4 = 1.85
tran 5u 60m uic
wrdata metering_unit_pwm_cold.dat i(Vs1) i(Vs2) i(Vs3) i(Vs4)

* Hot: the highest coil, 5 ohm, at +125 C (x1.382).
alter r1 = 6.91
alter r2 = 6.91
alter r3 = 6.91
alter r4 = 6.91
tran 5u 60m uic
wrdata metering_unit_pwm_hot.dat i(Vs1) i(Vs2) i(Vs3) i(Vs4)
.endc

.end

* ------------------------------------------------------------
* RESULT NOTE -- dither is a specification we do not have
* ------------------------------------------------------------
* This block shows what each frequency does to ripple. It cannot
* say which is RIGHT: the correct dither amplitude is a property of
* the specific metering unit's mechanics (friction, spring, mass),
* manufacturer data tied to the part number. The frequency is a
* firmware constant, so it can be tuned on the machine.
*
* Also not modelled: the coil's inductance is not constant. It falls
* as the armature moves and as the core approaches saturation. The
* 11.25 mH here is an assumption, chosen to keep 3 ms.
* ------------------------------------------------------------
*
* ------------------------------------------------------------
* RESULT NOTE -- history (decisions log 23, 25)
* ------------------------------------------------------------
* Until 18 Nov this file assumed a 10 ohm, 30 mH coil, and its cold
* and hot corners (7.39 / 13.82 ohm) missed the 0.675 A target by
* +28 % / -31 %. That was the finding that put current control on
* the board (R501, U501). The measured coil has a wider spread
* (1.85-6.91 ohm with temperature), so the open-loop misses are
* larger and current control matters more, not less. The control-law
* invariant (the three frequencies agree with each other) is still
* what says the PWM itself is sound, and it is checked at every
* corner.
* ------------------------------------------------------------
