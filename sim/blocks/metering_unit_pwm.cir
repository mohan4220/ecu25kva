* ============================================================
* Fuel metering unit driver -- ECU pin 88, low-side PWM
* ============================================================
* The metering unit sets rail pressure by throttling fuel into the
* high-pressure pump. It is a proportional solenoid, not a valve
* that is either open or shut, and what positions it is the
* AVERAGE current through the coil. The ECU's rail pressure loop
* closes onto the rail pressure sensor (pins 32/35/08) and its
* output is this PWM duty cycle.
*
* Spec section 2.2 corrected an earlier reading here: this is a
* single low-side PWM output on pin 88, not an H-bridge. The
* metering unit's other pin sits on fused battery (20 A, fuse
* 8F1), so the ECU switches the return path only.
*
* Coil, typical for a unit of this size: 10 ohm, 30 mH. At 13.5 V
* that is 1.35 A fully on, and an electrical time constant of
* L/R = 3 ms -- which is long compared with any sensible PWM
* period, and that is what makes the average-current control work.
*
* THE DESIGN CHOICE IS THE PWM FREQUENCY, and it is not simply
* "as high as possible". Ripple current at 50% duty is
*
*     dI = V * D * (1-D) * T / L
*
* so it falls as frequency rises. But a proportional solenoid has
* static friction, and a valve held at a perfectly constant
* current sticks and then jumps. Deliberate ripple -- dither --
* keeps it moving and makes the response smooth and repeatable.
* Too little dither and the valve is sticky; too much and the
* ripple modulates rail pressure directly.
*
* Three frequencies are run at the same 50% duty so the trade is
* visible as numbers:
*
*     100 Hz   period 10 ms, comparable to the coil's own 3 ms
*     1 kHz    period 1 ms
*     10 kHz   period 100 us, ripple essentially gone
*
* All three must produce the SAME average current, because that
* is the control law the pressure loop depends on. If average
* current moved with frequency, the loop's gain would depend on a
* constant nobody thinks about.
* ============================================================

.model NSW  SW(Ron=25m Roff=1e9 Vt=2.5 Vh=0.2)
* Freewheel diode. Same argument as the relay driver: interrupting
* 1.35 A in 30 mH with no path produces a spike that destroys the
* switch. Here it does a second job -- it sets how fast the
* current decays during the off-time, and so sets the ripple.
.model DFW  D(Is=1e-12 N=1.05 Rs=20m BV=200 IBV=1e-6)

Vbat bat 0 DC 13.5

* ---- 100 Hz ----
Vg1 g1 0 PULSE(0 5 0 1u 1u 5m 10m)
L1  bat a1 30m
R1  a1  b1 10
Vs1 b1  c1 0
S1  c1  0  g1 0 NSW
D1  c1  bat DFW

* ---- 1 kHz ----
Vg2 g2 0 PULSE(0 5 0 1u 1u 500u 1m)
L2  bat a2 30m
R2  a2  b2 10
Vs2 b2  c2 0
S2  c2  0  g2 0 NSW
D2  c2  bat DFW

* ---- 10 kHz ----
Vg3 g3 0 PULSE(0 5 0 100n 100n 50u 100u)
L3  bat a3 30m
R3  a3  b3 10
Vs3 b3  c3 0
S3  c3  0  g3 0 NSW
D3  c3  bat DFW

.control
* 60 ms is twenty coil time constants, so all three are in steady
* state well before the measurement window at the end.
tran 5u 60m uic
wrdata metering_unit_pwm.dat i(Vs1) i(Vs2) i(Vs3)

* ---- temperature corners: same three branches, R1/R2/R3 altered ----
* Copper's resistance-temperature coefficient is a physical constant,
* ~0.39%/C, sourced to copper itself: R = 10 * (1 + 0.0039*(T-25)).
* Cold (-40C): R=7.39 ohm (-26%). Hot (+125C): R=13.82 ohm (+38%).
* Done with `alter` + a second/third `tran`, not three more parallel
* branches: running six-plus switched RL branches off one ideal DC
* source in the same transient made ngspice's timestep collapse to
* ~1e-18 s around 5.5 ms ("trouble with node a1/a2") even with each
* corner given its own gate source -- a real ngspice convergence
* limit of this topology, not a modelling choice. Altering the SAME
* three branches' R and re-running keeps exactly the netlist's own
* marginal complexity instead of adding to it.
alter r1 = 7.39
alter r2 = 7.39
alter r3 = 7.39
tran 5u 60m uic
wrdata metering_unit_pwm_cold.dat i(Vs1) i(Vs2) i(Vs3)

alter r1 = 13.82
alter r2 = 13.82
alter r3 = 13.82
tran 5u 60m uic
wrdata metering_unit_pwm_hot.dat i(Vs1) i(Vs2) i(Vs3)
.endc

.end

* ------------------------------------------------------------
* RESULT NOTE -- dither is a specification we do not have
* ------------------------------------------------------------
* This block shows what each frequency does to ripple. It cannot
* say which is RIGHT, because the correct dither amplitude is a
* property of the specific metering unit's mechanics -- its
* friction, its spring, its mass -- and that is manufacturer data
* tied to the part number.
*
* The same gap as U5's injector calibration, in a smaller form:
* the electronics can be built to produce any dither asked for,
* and nobody has told us what to ask for. What this design can do
* is make the frequency a firmware constant rather than a
* hardware one, so it can be tuned on the machine without
* touching the board.
*
* Also not modelled: the coil's inductance is not constant. It
* falls as the armature moves and as the core approaches
* saturation, so real ripple at a given frequency varies across
* the duty range. The 30 mH here is a fixed mid-travel estimate.
* ------------------------------------------------------------
*
* ------------------------------------------------------------
* RESULT NOTE -- tolerance
* ------------------------------------------------------------
* Two components, and they bind two different checks:
*
*   L (30 mH) sets ripple. +/-20% (wound-inductor bin, same as
*   buck_preregulator's power inductor) moves ripple at 1 kHz from
*   0.118 A (nominal) to 0.099 A (+20%) / 0.148 A (-20%), and at
*   10 kHz from 0.012 A to 0.010 A / 0.015 A. Both stay inside their
*   checks' tolerance bands (0.113+/-0.05 and 0.011+/-0.008) at
*   either corner -- not sensitive. The "ripple scales as 1/f" check
*   is even less sensitive: both frequencies scale with 1/L equally,
*   so the ratio barely moves regardless of which way L goes.
*
*   R (10 ohm) sets mean current. 10 ohm is a class-typical figure
*   for a coil this size, INFERRED -- no metering unit part number
*   has been chosen. Wound-coil DC resistance commonly specifies at
*   +/-10% (automotive solenoid/relay coil datasheets typically use
*   this figure). Re-ran at R = 11 ohm (+10%, all three frequency
*   branches together, since it is the same physical coil measured
*   three ways) in a scratch copy, not this file:
*
*     R = 10 ohm (nominal)  mean current 0.634-0.639 A  PASS (want 0.675+/-0.09)
*     R = 11 ohm (+10%)     mean current 0.577-0.581 A  FAIL (0.004-0.008 A under)
*
* FLIPS, narrowly, and only on the high-R side (R = 9 ohm/-10% gives
* 0.709-0.710 A, comfortably inside). But look at what the three
* frequencies do AT the corner: 0.5809 / 0.5807 / 0.5767 A -- they
* still agree with each other to within a few mA, which is the
* actual claim the header makes ("all three must produce the SAME
* average current... the control law the pressure loop depends
* on"). What fails is closeness to 0.675 A specifically, a number
* that only means anything if the coil really is 10 ohm.
*
* THE TARGET IS NOT FULLY REAL here, in the same shape the review
* flagged for uncited round numbers elsewhere: 0.675 A is not a
* requirement anyone stated, it is this simulation's own prediction
* from an assumed, unsourced coil resistance. The rail-pressure loop
* is closed on the pressure sensor, not on an open-loop assumption
* about coil current, so a coil that turns out to be 11 ohm does not
* break anything the firmware depends on -- it just makes this one
* check's target wrong. The real invariant (frequency-independence)
* is what should gate PASS/FAIL here, and it does not move.
*
* Not fixed by widening the check's tolerance in this pass, because
* that would be weakening a check to make a corner pass, which the
* rules for this work explicitly rule out -- run_sim.py instead now
* carries a comment on this check explaining the distinction, so a
* future FAIL here is read correctly (coil resistance uncertainty,
* not a broken control law) rather than chased as a design defect.
* Also worth flagging and NOT modelled: copper's resistance rises
* with temperature (~0.39%/degC), and this coil dissipates real
* power (0.675 A^2 * 10 ohm =~ 4.6 W) inside an engine bay -- a hot
* coil pushes R further in the SAME direction that already flips
* this check, so treat the 11 ohm corner as optimistic, not
* pessimistic, once self-heating is considered. That is a thermal
* question this block does not simulate, the same kind of gap
* transient_clamp's RESULT NOTE leaves open for TVS temperature
* coefficient (2026-09-18 review F11) -- CLOSED for the TVS in this
* pass, see that file's own TEMPERATURE section; the self-heating
* question here specifically remains open, ambient is handled below.
* ------------------------------------------------------------
*
* ------------------------------------------------------------
* RESULT NOTE -- temperature
* ------------------------------------------------------------
* Closes the ambient half of the note above (self-heating is a
* separate, still-open question -- see above). Copper's resistance-
* temperature coefficient is a physical constant, ~0.39%/C, sourced
* to copper itself rather than any specific part. Over the full
* -40/+125 C ambient range (not counting any self-heating on top):
* R = 10 ohm * (1 + 0.0039*(T-25)):
*
*     -40 C   R = 7.39 ohm  (-26%)
*     +125 C  R = 13.82 ohm (+38%)
*
* Both are much larger swings than the +/-10% part-tolerance corner
* already run above. Re-ran the full three-frequency network at both
* in a scratch copy, not this file:
*
*                R=7.39 (cold)   R=10 (27C, nom)   R=13.82 (hot)
*   mean i1 (A)     0.862           0.639              0.463
*   mean i2 (A)     0.863           0.639              0.463
*   mean i3 (A)     0.858           0.634              0.459
*
* BOTH CORNERS FAIL THE "0.675 A" CHECK, in OPPOSITE directions --
* cold overshoots the 0.765 A ceiling by ~12%, hot undershoots the
* 0.585 A floor by ~21%, both well past the already-flagged 11 ohm
* corner's narrow miss (0.577-0.581 A). Ambient alone, no self-
* heating stacked on top, is a bigger effect than the part-to-part
* tolerance this file already used to make the point about the
* target being unreal.
*
* THE INVARIANT THAT ACTUALLY MATTERS SURVIVES BOTH CORNERS: the
* three frequencies still agree with each other to under 1% at
* either temperature (0.862/0.863/0.858 cold; 0.463/0.463/0.459
* hot), exactly the same shape the existing TOLERANCE section
* already established for the +10% R corner. This is the same
* conclusion, now shown to hold across the full ambient range, not
* just a part-tolerance bin: a "0.675 A" FAIL at either temperature
* extreme should be read as coil-resistance-vs-ambient doing exactly
* what copper does, not as the control law failing. The control law
* (frequency-independence) is what should gate PASS/FAIL, and it
* does not move.
*
* MOSFET Ron (25 mOhm nominal, up to ~50 mOhm at a doubled hot
* corner) was not separately swept: it is 500x smaller than the coil
* resistance even at its own worst case, and this check's numbers
* are utterly insensitive to it by construction.
*
* ENFORCED: the `alter`-based cold/hot re-runs in the .control block
* above, and check_metering_unit_pwm in run_sim.py, turn BOTH halves
* of this finding into checked claims, per the task's own instruction
* to express both rather than pick one. The "0.675 A" target check is
* the SAME check the nominal-27C lines already enforce -- running it
* at a corner is not a new/arbitrary target, it's the same claim at a
* condition the design has to survive, so it is allowed to genuinely
* FAIL (both directions). The control-law invariant (the three
* frequencies still agreeing with each other, under 1% spread) is a
* separate, real, tolerance-checked claim that PASSES at both
* corners -- that pass is what says the pressure loop's control law
* is not what's broken; the coil-resistance assumption behind
* "0.675 A" is.
* ------------------------------------------------------------
