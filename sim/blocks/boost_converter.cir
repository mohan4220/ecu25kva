* ============================================================
* Injector boost rail -- reservoir sizing
* Feeds ECU pins 03 and 05 (bank high sides)
* ============================================================
* The injector_boost block proved the rail is worth having: it
* cuts the time to reach 18 A peak from 439 us to 38 us, which is
* the difference between spending 44% of a 1 ms injection lifting
* the needle and spending 4%.
*
* This block sizes the thing that supplies it. The reservoir
* capacitor is the component that actually matters, because the
* boost converter cannot deliver 18 A -- it delivers a trickle
* and the capacitor delivers the pulse.
*
* Charge per injection event, peak phase only:
*     current ramps 0 -> 18 A over 38 us, mean 9 A
*     Q = 9 A * 38 us = 342 uC
* Droop on a 47 uF reservoir = 342 uC / 47 uF = 7.3 V, so a 100 V
* rail sags to about 93 V. That is acceptable: the rail's job is
* to be much larger than 13.5 V, not to be exactly 100 V.
*
* THE DESIGN QUESTION THIS BLOCK ANSWERS is where the HOLD phase
* gets its current. Two arrangements are simulated:
*
*   A  boost rail supplies the peak phase only; the hold current
*      comes from the battery through a separate path. This is
*      what production common-rail drivers do.
*
*   B  boost rail supplies peak AND hold. Superficially simpler --
*      one supply, one path.
*
* Hold is roughly 10 A for the rest of the injection. At 1 ms
* total that is 10 A * 962 us = 9.6 mC, twenty-eight times the
* peak phase's charge. Arrangement B is not a slightly worse
* version of A; it is a different order of magnitude, and the
* block exists to make that visible rather than asserted.
*
* Timing budget between events, from research memo 04: injections
* are 240 crank degrees apart, which at 1500 rpm is 26.67 ms. The
* recharge has that long, and the charger only needs to average
* the energy, not the peak.
* ============================================================

* ---- arrangement A: boost supplies the peak phase only ----
Ca   ra 0 47u ic=100
* Boost converter modelled as its average charging current. The
* switching detail does not matter for reservoir sizing -- what
* matters is charge in versus charge out.
* Regulated: charges at 50 mA until the rail reaches its 100 V
* setpoint, then stops. A plain DC source would keep pushing and
* the rail would climb past target -- which is what the first
* version of this netlist did, reporting a cheerful 122 V.
Bchga 0 ra I = v(ra) < 100 ? 50m : 0
* One injection event at 1 ms: ramp to 18 A over 38 us, then the
* boost rail is disconnected and the battery takes over the hold.
Iinja ra 0 PWL(0 0  1m 0  1.038m 18  1.0381m 0  30m 0)

* ---- arrangement B: boost supplies peak AND hold ----
Cb   rb 0 47u ic=100
Bchgb 0 rb I = v(rb) < 100 ? 50m : 0
* Same peak phase, then 10 A of hold for the rest of a 1 ms
* injection before releasing.
Iinjb rb 0 PWL(0 0  1m 0  1.038m 18  1.0381m 10  2m 10  2.0001m 0  30m 0)

.control
* 30 ms covers the event and most of the 26.67 ms available before
* the next cylinder fires, so the recharge is visible too.
tran 200n 30m uic
wrdata boost_converter.dat v(ra) v(rb)
.endc

.end

* ------------------------------------------------------------
* RESULT NOTE -- what this models and what it does not
* ------------------------------------------------------------
* Modelled: charge balance. Reservoir droop under a pulsed load,
* and whether the average charging current recovers it before the
* next event. That is the reservoir sizing question and it is
* answered here.
*
* NOT modelled: the boost converter itself. There is no inductor,
* no switch, no control loop -- just a current source standing in
* for its average output. That is deliberate and it is enough for
* sizing, but it means this block says nothing about the
* converter's stability, its inrush at power-up, or what happens
* when it is asked to recharge into an already-drooping rail.
*
* Also not modelled: arrangement B's real failure. The rail does
* not simply sag as drawn here -- it collapses toward the point
* where the driver can no longer regulate hold current at all,
* and the injector's behaviour past that is not linear. The
* simulated voltage after collapse should be read as "far below
* usable", not as a number.
*
* The hold current figure of 10 A is the middle of research memo
* 04's envelope (8-13 A). The envelope is family-wide, not this
* injector's measured value -- see U5.
*
* ALSO NOT MODELLED, found 18 Sep 2026 by injector_turnoff.cir:
* there is no bleed path on this reservoir. Bchga charges while
* v(ra) < 100 and stops above it, which regulates the rail from
* below and not at all from above. Nothing here can remove charge.
*
* That was harmless while the only current flowing was outward.
* injector_turnoff.cir now recirculates the injector's turn-off
* energy back INTO this capacitor, and its checks separate two
* cases:
*
*   peak-current cutoff   rail stays at 100.0002 V over three
*                         back-to-back events. The energy came
*                         out of this same rail microseconds
*                         earlier, so a lossless loop cancels by
*                         symmetry and real losses make it net
*                         negative.
*   hold-current cutoff   rail climbs to 101.995 V, about +2 V
*                         per event, and stays there.
*
* The difference is where the current came from. In arrangement A
* above, hold current is supplied by the BATTERY, not by this
* rail -- so recirculating it here is charge this capacitor never
* gave up, arriving with nothing to offset it and no way out.
*
* Whether that actually happens depends on whether hold-phase
* cutoffs share the same recirculation diode as full turn-off, a
* wiring question this block does not settle. If they do, this
* reservoir needs a bleed path and Bchga's one-sided regulation
* is not sufficient. Recorded here rather than in injector_turnoff
* because it is this block's component and this block's gap.
* ------------------------------------------------------------
*
* ------------------------------------------------------------
* RESULT NOTE -- tolerance
* ------------------------------------------------------------
* The candidate binding parameter is Ca/Cb, the 47 uF reservoir.
* Droop is Q/C with Q fixed by the injector's own current profile
* (342 uC, independent of C), so a smaller cap should show up
* directly as more droop. Neither dielectric class nor a part
* number is stated for this cap, so two corners were tried in
* scratch copies, not this file: -20% (a plain electrolytic's
* ordinary bin) and -60% (the MLCC DC-bias-near-rated-voltage loss
* this repo's other blocks use for caps biased close to their
* rating -- and a 100 V rail on a cap presumably rated for it is
* exactly that case, if it turns out to be an MLCC):
*
*     C = 47 uF (nominal)   droop_a  7.3 V, rail min  92.7 V
*     C = 37.6 uF (-20%)    droop_a  9.1 V, rail min  90.9 V
*     C = 18.8 uF (-60%)    droop_a 18.1 V, rail min  81.9 V
*
* All three clear the actual design floor -- "rail stays usefully
* above battery," checked in run_sim.py as >60 V -- by 20+ V even
* at the aggressive corner. That check does not flip.
*
* Recovery time is a separate question and turns out NOT to depend
* on C at all: time to recharge a fixed droop charge Q at a fixed
* current I is Q/I regardless of C (the C cancels -- droop is Q/C,
* recharge time is (Q/C)*C/I). Re-ran the -20% corner through the
* full 30 ms window and confirmed it: rail is back at 100.000 V by
* 7.78 ms after the event, indistinguishable from nominal's 6.84 ms
* and both far inside the 26.67 ms budget.
*
* So, like transient_clamp's C1: this block's real verdict --
* whether the rail stays usable and recovers in time -- does not
* depend on the reservoir capacitor's tolerance at any plausible
* corner. What DOES move is the "droop, peak phase only" check
* itself (run_sim.py, want 7.3 V, tol 1.5 V): that tolerance was
* set to confirm the SPICE model matches the hand calculation at
* the nominal 47 uF, not to encode real-world capacitor spread, and
* both corners above (9.1 V, 18.1 V) fall outside it. Read a FAIL
* there as "the part is not the nominal 47 uF assumed," not as a
* design failure -- the design floor two lines below it in the same
* check function is what the design actually has to clear, and it
* does, with room to spare.
*
* Charging current (50 mA, Bchga/Bchgb) was not swept the same way:
* it is not a passive component with a tolerance bin, it is this
* block's stand-in for the boost converter's own regulated average
* output, which is a control-loop property of a part not yet
* chosen. The margin on it is wide enough not to need it here
* anyway -- nominal recovery (6.84 ms) uses only a quarter of the
* 26.67 ms budget, so the charging current would have to be wrong
* by roughly 4x before this check's verdict moved.
* ------------------------------------------------------------
*
* ------------------------------------------------------------
* RESULT NOTE -- temperature
* ------------------------------------------------------------
* Already dominated by the existing TOLERANCE section, not a new
* mechanism needing a new run. Ca/Cb are ideal capacitors in this
* charge-balance model -- no ESR is modelled at all, so the
* electrolytic-ESR mechanism mcu_pdn.cir found sensitive does not
* even apply here (there is nothing in this netlist for it to act
* on). That leaves only capacitance value, which temperature moves
* by an amount smaller than what the TOLERANCE section already
* tried: X7R's own +/-15% envelope (if MLCC) or an electrolytic's
* -40 C capacitance loss (commonly 15-25%, INFERRED, class-typical)
* are both inside the -20%/-60% range already run above, and the
* -60% corner (18.8 uF) already cleared the >60 V design floor by
* 20+ V with room to spare. No plausible temperature-driven
* capacitance shift gets anywhere near that corner, so this does
* not need a separate run -- the existing tolerance sweep already
* covers it by construction, the same reasoning that section uses
* for why the recovery-time check does not depend on C at all.
* ------------------------------------------------------------
