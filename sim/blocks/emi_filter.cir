* ============================================================
* EMI input filter -- CISPR 25 conducted emissions
* Power chain stage 1, spec section 6
* ============================================================
* The buck stage switches 400 kHz of square-edged current out of
* the battery line. CISPR 25's conducted-emissions measurement
* starts at 150 kHz and runs to 108 MHz, and research memo 06
* puts this project at Class 5 -- the strictest class, 18 dBuV
* average in the FM band.
*
* The switching current has to be kept inside the box. This
* filter is what does it, and this block measures how well.
*
* Measurement setup follows the standard's voltage method: a
* 50 ohm source and a 50 ohm load, which is what the LISN
* presents. With Vs = 1 V AC and both 50 ohm, the unfiltered
* reference at the load is exactly 0.5 V, so insertion loss is
*     IL(dB) = 20*log10( v(out) / 0.5 )
* and comes out negative. The checks compare against that
* reference rather than against 1 V, which would report a
* free 6 dB the filter did not earn.
*
* Two stages, because one is not enough and the reason is
* instructive:
*
*   stage 1   L1 22 uH series, C1 4.7 uF shunt
*             Handles the fundamental and low harmonics. C1's own
*             ESL of ~1.5 nH puts its self-resonance near 1.9 MHz,
*             and ABOVE that frequency C1 is an inductor. A large
*             electrolytic or X7R bulk part stops filtering long
*             before the FM band the standard cares most about.
*
*   stage 2   lossy ferrite + C2 100 nF
*             Picks up where C1 gives out. The ferrite is modelled
*             as 0.5 uH in parallel with 120 ohm -- that parallel
*             resistance is the point of a ferrite as opposed to
*             an inductor: it DISSIPATES the high-frequency energy
*             instead of storing it and ringing with the next
*             capacitor along.
*
*   damper    Rd + Cd across C2. Needed, and the netlist without it
*             showed why: the ferrite's 0.5 uH and C2's 100 nF form
*             a tank at 712 kHz, and undamped it clawed back 12 dB
*             of attenuation right there -- the worst point in the
*             whole band sat on top of the switching fundamental's
*             second harmonic. The tank's characteristic impedance
*             is sqrt(L/C) = 2.24 ohms, so a 2.2 ohm damper in
*             series with a capacitor big enough to be invisible at
*             that frequency brings Q to about 1. Cd is 10x C2 so
*             the damper looks resistive across the whole peak.
* ============================================================

Vs  s 0 AC 1
Rs  s a 50

* ---- stage 1 ----
L1  a b 22u
C1  b c1 4.7u
Rc1 c1 c2 5m
Lc1 c2 0  1.5n

* ---- stage 2: lossy ferrite bead ----
Lf  b d 0.5u
Rf  b d 120

C2  d e1 100n
Rc2 e1 e2 20m
Lc2 e2 0  0.5n

* Damping branch -- see the header. Cd is large enough that this
* branch is essentially 2.2 ohms resistive across the resonance.
Cd  d dp 1u
Rd  dp 0 2.2

Rl  d 0 50

* ---- reference network: no filter, same 50/50 ----
Vs2 s2 0 AC 1
Rs2 s2 r 50
Rl2 r  0 50

.control
ac dec 200 10k 200meg
wrdata emi_filter.dat vdb(d) vdb(r)
.endc

.end

* ------------------------------------------------------------
* RESULT NOTE -- differential mode only
* ------------------------------------------------------------
* This models DIFFERENTIAL-mode attenuation: noise between
* battery positive and return. Real automotive conducted-emissions
* failures are frequently COMMON mode -- both wires swinging
* together against the chassis -- and a differential filter does
* essentially nothing for that.
*
* Common mode is what the common-mode choke in spec section 6 is
* for, and it cannot be modelled honestly as a two-terminal part:
* it needs a coupled-inductor model and a defined chassis return
* path, which is a layout property this board does not have yet.
*
* So: this block sizes the differential stage. The common-mode
* choke stays a specification, not a simulated result, until
* there is a layout to model it against. Recorded rather than
* quietly omitted.
*
* TOLERANCE -- the checks at 150 kHz and 400 kHz pass at nominal by
* 1.17 dB and 1.55 dB, the thinnest margins in this repo. The two
* parameters that move those numbers: L1 (power inductor, +/-20% is
* standard for this class of part) and C1 (4.7 uF MLCC, sitting
* directly on the battery line biased to 40 V -- MLCC capacitance
* under DC bias can lose up to ~60% of its rated value near the
* part's voltage rating, a well-documented X7R/X5R effect, worse
* the smaller and higher-K the part). Re-ran at L1 -20% (17.6 uH)
* and C1 -60% (1.88 uF) in a scratch copy, not this file:
*
*     nominal          IL@150kHz -41.17 dB   IL@400kHz -51.55 dB
*     L1-20%/C1-60%    IL@150kHz -33.6  dB   IL@400kHz -42.4  dB
*
* Both flip from PASS to FAIL against the -40/-50 dB gates.
*
* What this does NOT show is that the filter is inadequate. Those
* gates are round numbers chosen before any hardware measurement of
* this board's unfiltered emissions exists -- see the check file's
* own "is 40 dB enough for Class 5?" line, answered "unknown" for
* every one of these checks, nominal or tolerance-corner alike. A
* margin this thin against an unvalidated target is worth knowing
* -- it says the -40/-50 dB gates are fragile to ordinary component
* tolerance, not just to interpretation -- but flipping them to FAIL
* here would manufacture a verdict this block cannot support either
* way. The honest reading: this filter's margin against ITS OWN
* placeholder target is not robust, and the placeholder target
* itself still needs a LISN measurement to mean anything. Fixing
* the margin (tighter-tolerance L1, a C1 sized or biased so its
* DC-bias loss is smaller, e.g. a larger case size or a part rated
* well above 40 V) is worth doing on cost/robustness grounds
* regardless of what the eventual measured target turns out to be.
* ------------------------------------------------------------
*
* ------------------------------------------------------------
* RESULT NOTE -- temperature
* ------------------------------------------------------------
* C1 is X7R (stated in the TOLERANCE section above). "X7R" is not a
* class description here, it is an EIA/AVX dielectric CODE: X = -55 C
* low-temp limit, 7 = +125 C high-temp limit, R = +/-15% MAXIMUM
* capacitance change anywhere across that range, referenced to its
* 25 C value. That +/-15% is the definition of the part, not an
* INFERRED figure -- and per the task brief's own framing, X7R loses
* capacitance at BOTH temperature extremes (a shallow "smile" curve
* around room temperature), so -15% is a legitimate worst-case bound
* at EITHER end of this design's -40/+125 C range, even though that
* range sits inside the wider -55/+125 C the code itself certifies.
*
* Re-ran the AC network (ngspice `.temp` has nothing to move here --
* passive values, not junctions) at C1 = 4.7 uF * 0.85 = 3.995 uF,
* L1 held at nominal (isolating the temperature mechanism from the
* DC-bias one already in the TOLERANCE section), in a scratch copy,
* not this file:
*
*     nominal (C1=4.70 uF)          IL@150kHz -41.09 dB   IL@400kHz -51.60 dB
*     temp only (C1=3.995 uF, -15%) IL@150kHz -39.75 dB   IL@400kHz -50.12 dB
*
* THIS FLIPS THE 150 kHz CHECK BY ITSELF. No DC-bias derate, no L1
* tolerance, no part-to-part spread -- just C1's OWN DEFINED
* temperature behaviour, the thing "X7R" on the BOM line already
* promises it will do, is enough on its own to fail the -40 dB gate
* (by 0.25 dB) and leave the 400 kHz gate with 0.12 dB of margin,
* effectively none. This is the same finding the TOLERANCE section
* already reported for DC bias, now shown to not even need DC bias
* to happen -- the "thinnest margin in this repo" comment at the top
* of that section was not overstating it.
*
* Stacked with the DC-bias corner already in the file (C1 at -60%
* bias derate AND -15% temperature together, C1=1.60 uF, L1 still at
* its own -20% tolerance corner):
*
*     DC-bias only (existing)          IL@150kHz -33.64 dB   IL@400kHz -42.40 dB
*     DC-bias + temperature (stacked)  IL@150kHz -32.47 dB   IL@400kHz -40.97 dB
*
* Temperature adds a further ~1.2-1.4 dB on top of an already-failing
* corner -- worse, but not the headline finding; the headline is that
* temperature ALONE, un-stacked, already flips one gate and guts the
* other. Same caveat the TOLERANCE section already states applies
* here too: the -40/-50 dB gates are themselves placeholders pending
* a LISN measurement, so this is not "the filter fails," it is "this
* filter's margin against its OWN placeholder target evaporates from
* ordinary, specified X7R behaviour before any tolerance or bias
* effect is even considered." A larger-case or higher-voltage-rated
* C1 (already recommended above for the DC-bias finding) would help
* here for the same underlying reason -- more dielectric volume per
* farad generally derates less over both bias and temperature -- but
* that is a part-selection question, not something changed here.
* ------------------------------------------------------------
